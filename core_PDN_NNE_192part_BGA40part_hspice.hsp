* Top level spice file

.option post=1
*.chkanode type=gate dv=0.5*pvdd report=active
.option parhier = local
.option measform = 1
.option lis_new
.option post probe
.param pi = 3.141592653

*** 200G RAM needed ***

*************************************** Input params **************************
.param Vdd 	= 0.775

.param is_use_ecap_ebed = 1		*** value: 0 or 1, note: this could be baked in pkg model
.param ecap_choice = 0  *** 0:baseline; 1: Samsung SCRLLC106MG6EGNNWT 10.56uF; 2: Samsung SCRLLC885MG6EGNNWT 8.87uF ; -1: mockup connection to bump grp
*** ecap config info, slide 8 of https://docs.google.com/presentation/d/1orH5VIG1UrYzCUIHZ60a6fJnd-Fa2yBdIXBZB8ctO6Q/edit?slide=id.g399c8a40ad7_4_0#slide=id.g399c8a40ad7_4_0

.param is_use_MIM 		= 0		*** No MIM die model as of 11/26/2025
.param is_MIM_exp_24x8 	= 0		*** experiment for 24x8 MIM
.param is_bump_DTC      = 0     *** experiment bump level DTC

.param induct_eqvlnt_r =  0.m   *** DCR of inductor of ALL phases, use 0.0m if PMIC_opt ==3, use 0.07m if run ideal voltage src
.param PMIC_opt = 1				*** 1: ideal voltage src; 2:ideal voltage src w/ VCVS feedback; 3: voltage src using pwl
*** NOTE: ONLY applicable if PMIC_opt == 3
* .param volt_src = str('./hspice_inc/MAX20420_40_Top_schem_DL_6phase_ENC8_LL_241209_25MHz_simplify_250307_V_PMIC_out.csv')	*** derived from B0 current "NNE_0p25_PA_resnet_noReLU_250304", no stagger
* .param volt_src = str('./hspice_inc/MAX20420_40_Top_schem_DL_6phase_ENC8_LL_241209_25MHz_simplify_250309_V_PMIC_out.csv')	*** derived from B0 current "NNE_0p25_PA_resnet_noReLU_250304", 50ns stagger, use current profile accordingly !!
* .param volt_src = str('./hspice_inc/VpmicOUT_NNE_0p25_PA_IGI_power_test_rivbev_bb_res2_250408.txt_simplis.BW25MHz.csv')
* .param volt_src = str('./hspice_inc/MAX20420_40_Top_schem_DL_6phase_ENC8_LL_241209_25MHz_simplify_sival_32nH_250409_Vpmic_out_modif.csv')  ***  nne valiadation test2, PMIC load line mode, only one PA+IGI parition running, others idling

* .param volt_src = str('./hspice_inc/nne_test_2_4xPart_Vpmic_OUT_BW_25MHz.csv') 	*** nne validation test2, all 4 paritions running, loadline mode
.param volt_src = str('./hspice_inc/ADI_MAX20420_40_Top_schem_DL_6phase_ENC5_Integrator240916_25MHz_simplify_testcase3_rivbev_bb_res2_test2.csv') 	*** nne validation test2, all 4 paritions running, ADI integrator mode

* .param volt_src = str('./hspice_inc/MPQ2946_MPQ86761_For_Rivian_Encrypted_VpmicOUT.csv') 	*** nne validation test2, all 4 paritions running, DC loadline mode, MPS 250711
* .param volt_src = str('./hspice_inc/MPQ2946_MPQ86761_For_Rivian_Enc_ACloadline.csv') 	*** nne validation test2, all 4 paritions running, AC loadline mode, MPS 250716

.param volt_src = str('./hspice_inc/EP9501_EP7503_Rivian_TB_26062401.sxgpx_V_VR_StartFr_0_v2.csv') 	*** 260701 EMpwr IVR teset, 83us, corresponding to "core_PDN_NNE_192part_BGA40part_hspice.tr26043001 "

.param Vdd_shift_fr_pwl = -0.01

.param is_ac_run = 1		*** 1 if impedance, 0 if transient

* .param is_row_0_active = 1	***
* .param is_row_1_active = 0	***
* .param is_row_2_active = 0	***
* .param is_row_3_active = 0	***

.param td_delay_stag = 0.n
.param td_delay_grp0 =  '0.* td_delay_stag'
.param td_delay_grp1 =  '1.* td_delay_stag'
.param td_delay_grp2 =  '2.* td_delay_stag'
.param td_delay_grp3 =  '3.* td_delay_stag'

* .param td_delay_perCol_stag = 0.n
* .param td_delay_perCol_grp0 =  '0.* td_delay_perCol_stag'
* .param td_delay_perCol_grp1 =  '1.* td_delay_perCol_stag'
* .param td_delay_perCol_grp2 =  '2.* td_delay_perCol_stag'
* .param td_delay_perCol_grp3 =  '3.* td_delay_perCol_stag'

	* *** not used when CPM is enabled
	* .param Cdie_coeff = 1.0				*** ONLY multi grp controlling, use 1.0 if no Cdie scaling, use 3.62 for NNE if MIM cap is added,
	* .param Rdie_coeff = 1.0				*** Rdie is constant 1. , rather than scaled by '1./Cdie_coeff'

	* *** Cdie Rdie based on MAM-242, tau = 24.26 (excluding MIM)
	* .param Cdie_PA 	= '130.3n * Cdie_coeff'
	* .param Cdie_MA 	= '101.7n * Cdie_coeff'
	* .param Rdie_PA 	= '0.186m * Rdie_coeff'
	* .param Rdie_MA 	= '0.239m * Rdie_coeff'
	* .param Rleak 	= 0.84

*************************************** User defined functions ****************
.param V_meas(node, ref) = 'v(node) - v(ref)'

*************************************** Input Models**************************
***** define load current source model used in die model *****
*** !!! Check before change any current profile   !!!!
*** additional background DC current (mainly to help decompose profile and smoother staggering, this will require original profile to remove DC values)
* .param is_use_backgnd_cur = 0
* .param curr_backgnd_PA_1_col = 0.915  		* old: 1.625
* .param curr_backgnd_MA_1_col = 0.535 		* old: 0.95

.param curr_backgnd_PA_1_tile = 0.1525
.param curr_backgnd_MA_1_tile = 0.089167

.param tStep	= 10.p
.param tStop	= 105.u     ** 83.u

.param is_curr_defined_external = 1 		*** 1: if current sources files defined externally;
											*** 0: if define current sources within in this file

.if (is_curr_defined_external == 1 )
	*** ONLY 1 of these can be active, all others need to be commented
	* .inc /data/home/jiangongwei/work/PDN_core/hspice_inc/curr_profile_NNE_24x8part_251120_Ashwin_idle_perTile.scp				*** all Ashwin per tile idle power, 35us

	* .inc /data/home/jiangongwei/work/PDN_core/hspice_inc/curr_profile_NNE_24x8part_260107_idle_perTile.scp				*** all idle power, TT corner, 85 deg, 260107 (much closer power to measurement)
	* .inc /data/home/jiangongwei/work/PDN_core/hspice_inc/curr_profile_NNE_24x8part_251215_Ashwin_idle_perTile.scp				*** all idle power, TT corner, 85 deg
	* .inc /data/home/jiangongwei/work/PDN_core/hspice_inc/curr_profile_NNE_24x8part_idle_2Gclk_PerTile.scp						*** 251203, 4x idle, 35us
	* .inc /data/home/jiangongwei/work/PDN_core/hspice_inc/curr_profile_NNE_24x8part_260126_B0_idle_perTile.scp					*** 260126, 4x partition idle, B0 database
	* .inc /data/home/jiangongwei/work/PDN_core/hspice_inc/curr_profile_NNE_24x8part_260126_A0_idle_125C_perTile.scp				*** 260202, all idle, A0, 125C
	* .inc /data/home/jiangongwei/work/PDN_core/hspice_inc/curr_profile_NNE_24x8part_260126_B0_idle_125C_perTile.scp				*** 260202, all idle, B0, 125C

	* .inc /data/home/jiangongwei/work/PDN_core/hspice_inc/curr_profile_NNE_24x8part_Row0_5Active_OthersIdle_PerTile.scp		*** Active share same csv, idle Ashwin per tile , 35us

	* .inc /data/home/jiangongwei/work/PDN_core/hspice_inc/curr_profile_NNE_24x8part_Row0_5Active_ZeroDataZeroWt_PerTile_OthersIdle_PerTile.scp	*** 251204 1 partition active w/ diff variations, 3x idle, 35us
	* .inc /data/home/jiangongwei/work/PDN_core/hspice_inc/curr_profile_NNE_24x8part_Row0_5Active_ZeroDataSameWt_PerTile_OthersIdle_PerTile.scp
	* .inc /data/home/jiangongwei/work/PDN_core/hspice_inc/curr_profile_NNE_24x8part_Row0_5Active_SameDataZeroWt_PerTile_OthersIdle_PerTile.scp

	* .inc /data/home/jiangongwei/work/PDN_core/hspice_inc/curr_profile_NNE_24x8part_Row0_5Active_PerTile_OthersIdle_PerTile.scp	 *** Active and Idle are all Ashwin per tile , 35us
	* .inc /data/home/jiangongwei/work/PDN_core/hspice_inc/curr_profile_NNE_24x8part_Row0_5Active_PerTilePwrX2_OthersIdle_PerTile.scp		*** Active pwr x 2,  and Idle are all Ashwin per tile , 35us
	* .inc /data/home/jiangongwei/work/PDN_core/hspice_inc/curr_profile_NNE_24x8part_Row0_5Active251215_PerTile_OthersIdle_PerTile.scp	*** 251215, Ashwin ramp_up_0_ramp_down_0, 45us

	* .inc /data/home/jiangongwei/work/PDN_core/hspice_inc/curr_profile_NNE_24x8part_Row0_5Active_PerTile_OthersIdle_PerTile_260108.scp	*** 260108, fixed mapping for active partition, 45us, idle same as  'curr_profile_NNE_24x8part_260107_idle_perTile'
	* .inc /data/home/jiangongwei/work/PDN_core/hspice_inc/curr_profile_NNE_24x8part_Row0_5ActivePwrVirus_PerTile_OthersIdle_PerTile_260213.scp	*** 260213, 7us, active parition runs POWER VIRUS, others idle
	* .inc /data/home/jiangongwei/work/PDN_core/hspice_inc/curr_profile_NNE_24x8part_Row18_23Active_PerTile_OthersIdle_PerTile_260108.scp    *** 260316, innermost partition active, others idle
	* .inc /data/home/jiangongwei/work/PDN_core/hspice_inc/curr_profile_NNE_24x8part_Row0_5Active_PerTile_OthersIdle_PerTile_B0_260326.scp	*** (path outdated) 260326, B0 Attention waveform, beachfront active, other partitions idle (B0 version), 105us

	* .inc /data/home/jiangongwei/work/PDN_core/hspice_inc/curr_profile_NNE_24x8part_Row0_5Active_PerTile_OthersIdle_PerTile_B0_260903.scp	*** 260903, B0 Attention waveform, beachfront active, other partitions idle (B0 version), 105us
	.inc /data/home/jiangongwei/work/PDN_core/hspice_inc/curr_profile_NNE_24x8part_Row18_23Active_PerTile_OthersIdle_PerTile_B0_260903.scp  *** 260903, B0 Attention waveform, innermost active, other partitions idle (B0 version), 105us
	* .inc /data/home/jiangongwei/work/PDN_core/hspice_inc/curr_profile_NNE_24x8part_Row0_23Active_PerTile_B0_260903.scp						*** 260903, all partitions active

	* .inc /data/home/jiangongwei/work/PDN_core/hspice_inc/curr_profile_NNE_24x8part_Row0_11Active_PerTile_OthersIdle_PerTile_260108.scp		 *** 260322, Row0-5, 6-11, i.e., 2 partitions active w/ 260108 current, other two idel

	* .inc /data/home/jiangongwei/work/PDN_core/hspice_inc/curr_profile_NNE_24x8part_AllRowActive_PerTile_same_curr.scp			*** All using previous same tile profile, 189us
	* .inc /data/home/jiangongwei/work/PDN_core/hspice_inc/curr_profile_NNE_24x8part_AllColActive_PerTile.scp						*** all 4 part. using same per tile active profile, 35us
	* .inc /data/home/jiangongwei/work/PDN_core/hspice_inc/curr_profile_NNE_24x8part_AllColActive_PerTile_260108.scp				*** 45us, using updated active parition from 260108

	* .inc /data/home/jiangongwei/work/PDN_core/hspice_inc/curr_profile_NNE_24x8part_pa_fd_24cc_cnn_2x4_nkc32_clip_max_test_1_A0_PerTile.scp	*** 251202, Ashwin Hand created Max power test, 60us

.endif

.if (is_curr_defined_external == 0 )
	.param pwl_file_in_PA_1_tile = str('/data/home/jiangongwei/work/PDN_core/hspice_inc/NNE_perTile_1Over24_PA_power_test_rivbev_bb_res2_250407.txt.csv')
	.param pwl_file_in_MA_1_tile = str('/data/home/jiangongwei/work/PDN_core/hspice_inc/NNE_perTile_1Over24_IGI_power_test_rivbev_bb_res2_250407.txt.csv')
.endif

		*** idle current
		.param pwl_file_quiet = str('./hspice_inc/curr_quiet_30us.txt.csv')

*** filter for measurement
.subckt meas_filter
+ pin_in  ref_gnd 	hf  lf

E_meas pin_meas ref_gnd  pin_in ref_gnd	1.0

C_hf pin_meas	hf  	160.p
R_hf hf         ref_gnd 1k

R_lf pin_meas	lf		1k
C_lf lf 		ref_gnd	160.p
.ends meas_filter

*** bump level DTC model
.subckt siCap_bump_samsung_SCTAAX165M74EGTABT
+ bump_die  bump_pkg ref_gnd
	*** top level serial RLC
	c_top  bump_die  node0	1.66u
	l_top  node0  node1  0.22p
	r_top  node1 ref_gnd 3.1m
	*** top to bottom RL
	l_vrtcl bump_die  node2 6.p
	r_vrtcl node2 bump_pkg  0.4m
.ends siCap_bump_samsung_SCTAAX165M74EGTABT

.subckt siCap_bump_samsung_0p4mmX1mm		*** top pitch 45um/diamter 25um; bottom pitch 130um, diamter 40um
+ bump_die  bump_pkg ref_gnd R_mt_top= 0.07m L_mt_top= 0.065p  R_mt_bot= 0.29m L_mt_bot= 0.62p
	*** top level serial RLC
	r_top_mt bump_die  node_mt_top_0   		R_mt_top
	l_top_mt node_mt_top_0   node_mt_top_1 	L_mt_top
	c_top  node_mt_top_1  node0		0.664u
	l_top  node0  node1  			0.55p
	r_top  node1 ref_gnd 			7.75m
	*** top to bottom RL
	l_vrtcl bump_die  node2 		15.p
	r_vrtcl node2  node_mt_bot_0 	1.0m
	r_bot_mt node_mt_bot_0 node_mt_bot_1 	R_mt_bot
	l_bot_mt node_mt_bot_1	bump_pkg		L_mt_bot
.ends siCap_bump_samsung_0p4mmX1mm

*** Ecap EC2005P, 9.34uF (R_mt, L_mt is per sub-cap)
.subckt siCap_EC2005P
+ capPort1 capPort2 ref_gnd R_mt=15.5u	L_mt=14.0p
	r_mt1 CapPort1 	mt1_1	R_mt
	l_mt1 mt1_1  	mt1_2	L_mt
	r_cap_esl1	mt1_2	mt1_3	5.m
	l_cap_esl1	mt1_3	mt1_4	2.p
	c_cap_1	mt1_4 	ref_gnd	4.67u

	r_mt2 CapPort2 	mt2_1	R_mt
	l_mt2 mt2_1  	mt2_2	L_mt
	r_cap_esl2	mt2_2	mt2_3	5.m
	l_cap_esl2	mt2_3	mt2_4	2.p
	c_cap_2	mt2_4 	ref_gnd	4.67u
.ends siCap_EC2005P

*** Ecap EC2005P_hf, 4.67uF (R_mt, L_mt is per sub-cap)
.subckt siCap_EC2005P_hf
+ capPort1 capPort2 ref_gnd R_mt=31.u	L_mt=28.0p
	r_mt1 CapPort1 	mt1_1	R_mt
	l_mt1 mt1_1  	mt1_2	L_mt
	r_cap_esl1	mt1_2	mt1_3	10.m
	l_cap_esl1	mt1_3	mt1_4	4.p
	c_cap_1	mt1_4 	ref_gnd	2.335u

	r_mt2 CapPort2 	mt2_1	R_mt
	l_mt2 mt2_1  	mt2_2	L_mt
	r_cap_esl2	mt2_2	mt2_3	10.m
	l_cap_esl2	mt2_3	mt2_4	4.p
	c_cap_2	mt2_4 	ref_gnd	2.335u
.ends siCap_EC2005P_hf

*** Ecap EC2005P_qt, 2.335uF (R_mt, L_mt is per sub-cap)
.subckt siCap_EC2005P_qt
+ capPort1 ref_gnd R_mt=62.u	L_mt=56.0p
	r_mt1 CapPort1 	mt1_1	R_mt
	l_mt1 mt1_1  	mt1_2	L_mt
	r_cap_esl1	mt1_2	mt1_3	10.m
	l_cap_esl1	mt1_3	mt1_4	4.p
	c_cap_1	mt1_4 	ref_gnd	2.335uF
.ends siCap_EC2005P_qt

*** each sub-cap split into 2
.subckt siCap_EC2005P_4Part
+ capPort1 capPort2 capPort3 capPort4 ref_gnd R_mt=31.0u	L_mt=28.0p 		*** POR
	r_mt1 			CapPort1 	mt1_1	R_mt
	l_mt1 			mt1_1  	mt1_2	L_mt
	r_cap_esl1		mt1_2	mt1_3	10.m
	l_cap_esl1		mt1_3	mt1_4	4.p
	c_cap_1			mt1_4 	ref_gnd	2.335u

	r_mt2 			CapPort2 	mt2_1	R_mt
	l_mt2 			mt2_1  	mt2_2	L_mt
	r_cap_esl2		mt2_2	mt2_3	10.m
	l_cap_esl2		mt2_3	mt2_4	4.p
	c_cap_2			mt2_4 	ref_gnd	2.335u

	r_mt3 			CapPort3 	mt3_1	R_mt
	l_mt3 			mt3_1  	mt3_2	L_mt
	r_cap_esl3		mt3_2	mt3_3	10.m
	l_cap_esl3		mt3_3	mt3_4	4.p
	c_cap_3			mt3_4 	ref_gnd	2.335u

	r_mt4 			CapPort4 	mt4_1	R_mt
	l_mt4 			mt4_1  	mt4_2	L_mt
	r_cap_esl4		mt4_2	mt4_3	10.m
	l_cap_esl4		mt4_3	mt4_4	4.p
	c_cap_4			mt4_4 	ref_gnd	2.335u
.ends siCap_EC2005P_4Part

.subckt siCap_EC2005P_4Part_RLx0p9
+ capPort1 capPort2 capPort3 capPort4 ref_gnd R_mt=27.9u	L_mt=25.2p 		*** POR
	r_mt1 			CapPort1 	mt1_1	R_mt
	l_mt1 			mt1_1  	mt1_2	L_mt
	r_cap_esl1		mt1_2	mt1_3	9.m
	l_cap_esl1		mt1_3	mt1_4	3.6p
	c_cap_1			mt1_4 	ref_gnd	2.335u

	r_mt2 			CapPort2 	mt2_1	R_mt
	l_mt2 			mt2_1  	mt2_2	L_mt
	r_cap_esl2		mt2_2	mt2_3	9.m
	l_cap_esl2		mt2_3	mt2_4	3.6p
	c_cap_2			mt2_4 	ref_gnd	2.335u

	r_mt3 			CapPort3 	mt3_1	R_mt
	l_mt3 			mt3_1  	mt3_2	L_mt
	r_cap_esl3		mt3_2	mt3_3	9.m
	l_cap_esl3		mt3_3	mt3_4	3.6p
	c_cap_3			mt3_4 	ref_gnd	2.335u

	r_mt4 			CapPort4 	mt4_1	R_mt
	l_mt4 			mt4_1  	mt4_2	L_mt
	r_cap_esl4		mt4_2	mt4_3	9.m
	l_cap_esl4		mt4_3	mt4_4	3.6p
	c_cap_4			mt4_4 	ref_gnd	2.335u
.ends siCap_EC2005P_4Part_RLx0p9

.subckt siCap_EC2005P_4Part_RLx0p7
+ capPort1 capPort2 capPort3 capPort4 ref_gnd R_mt=21.7u	L_mt=19.6p 		*** POR
	r_mt1 			CapPort1 	mt1_1	R_mt
	l_mt1 			mt1_1  	mt1_2	L_mt
	r_cap_esl1		mt1_2	mt1_3	7.m
	l_cap_esl1		mt1_3	mt1_4	2.8p
	c_cap_1			mt1_4 	ref_gnd	2.335u

	r_mt2 			CapPort2 	mt2_1	R_mt
	l_mt2 			mt2_1  	mt2_2	L_mt
	r_cap_esl2		mt2_2	mt2_3	7.m
	l_cap_esl2		mt2_3	mt2_4	2.8p
	c_cap_2			mt2_4 	ref_gnd	2.335u

	r_mt3 			CapPort3 	mt3_1	R_mt
	l_mt3 			mt3_1  	mt3_2	L_mt
	r_cap_esl3		mt3_2	mt3_3	7.m
	l_cap_esl3		mt3_3	mt3_4	2.8p
	c_cap_3			mt3_4 	ref_gnd	2.335u

	r_mt4 			CapPort4 	mt4_1	R_mt
	l_mt4 			mt4_1  	mt4_2	L_mt
	r_cap_esl4		mt4_2	mt4_3	7.m
	l_cap_esl4		mt4_3	mt4_4	2.8p
	c_cap_4			mt4_4 	ref_gnd	2.335u
.ends siCap_EC2005P_4Part_RLx0p7

.subckt siCap_EC2005P_4Part_RLx0p5
+ capPort1 capPort2 capPort3 capPort4 ref_gnd R_mt=15.5u	L_mt=14.p 		*** POR
	r_mt1 			CapPort1 	mt1_1	R_mt
	l_mt1 			mt1_1  	mt1_2	L_mt
	r_cap_esl1		mt1_2	mt1_3	5.m
	l_cap_esl1		mt1_3	mt1_4	2.p
	c_cap_1			mt1_4 	ref_gnd	2.335u

	r_mt2 			CapPort2 	mt2_1	R_mt
	l_mt2 			mt2_1  	mt2_2	L_mt
	r_cap_esl2		mt2_2	mt2_3	5.m
	l_cap_esl2		mt2_3	mt2_4	2.p
	c_cap_2			mt2_4 	ref_gnd	2.335u

	r_mt3 			CapPort3 	mt3_1	R_mt
	l_mt3 			mt3_1  	mt3_2	L_mt
	r_cap_esl3		mt3_2	mt3_3	5.m
	l_cap_esl3		mt3_3	mt3_4	2.p
	c_cap_3			mt3_4 	ref_gnd	2.335u

	r_mt4 			CapPort4 	mt4_1	R_mt
	l_mt4 			mt4_1  	mt4_2	L_mt
	r_cap_esl4		mt4_2	mt4_3	5.m
	l_cap_esl4		mt4_3	mt4_4	2.p
	c_cap_4			mt4_4 	ref_gnd	2.335u
.ends siCap_EC2005P_4Part_RLx0p5

.subckt siCap_EC2005P_4Part_RLx0p19
+ capPort1 capPort2 capPort3 capPort4 ref_gnd R_mt=15.5u	L_mt=14.p 		*** POR
	r_mt1 			CapPort1 	mt1_1	R_mt
	l_mt1 			mt1_1  	mt1_2	L_mt
	r_cap_esl1		mt1_2	mt1_3	1.9m
	l_cap_esl1		mt1_3	mt1_4	0.76p
	c_cap_1			mt1_4 	ref_gnd	2.335u

	r_mt2 			CapPort2 	mt2_1	R_mt
	l_mt2 			mt2_1  	mt2_2	L_mt
	r_cap_esl2		mt2_2	mt2_3	1.9m
	l_cap_esl2		mt2_3	mt2_4	0.76p
	c_cap_2			mt2_4 	ref_gnd	2.335u

	r_mt3 			CapPort3 	mt3_1	R_mt
	l_mt3 			mt3_1  	mt3_2	L_mt
	r_cap_esl3		mt3_2	mt3_3	1.9m
	l_cap_esl3		mt3_3	mt3_4	0.76p
	c_cap_3			mt3_4 	ref_gnd	2.335u

	r_mt4 			CapPort4 	mt4_1	R_mt
	l_mt4 			mt4_1  	mt4_2	L_mt
	r_cap_esl4		mt4_2	mt4_3	1.9m
	l_cap_esl4		mt4_3	mt4_4	0.76p
	c_cap_4			mt4_4 	ref_gnd	2.335u
.ends siCap_EC2005P_4Part_RLx0p5

.subckt siCap_EC2005P_4Part_RL_LowESRL
+ capPort1 capPort2 capPort3 capPort4 ref_gnd R_mt=15.5u	L_mt=14.p 		*** POR
	r_mt1 			CapPort1 	mt1_1	R_mt
	l_mt1 			mt1_1  	mt1_2	L_mt
	r_cap_esl1		mt1_2	mt1_3	1.f
	l_cap_esl1		mt1_3	mt1_4	1.f
	c_cap_1			mt1_4 	ref_gnd	2.335u

	r_mt2 			CapPort2 	mt2_1	R_mt
	l_mt2 			mt2_1  	mt2_2	L_mt
	r_cap_esl2		mt2_2	mt2_3	1.f
	l_cap_esl2		mt2_3	mt2_4	1.f
	c_cap_2			mt2_4 	ref_gnd	2.335u

	r_mt3 			CapPort3 	mt3_1	R_mt
	l_mt3 			mt3_1  	mt3_2	L_mt
	r_cap_esl3		mt3_2	mt3_3	1.f
	l_cap_esl3		mt3_3	mt3_4	1.f
	c_cap_3			mt3_4 	ref_gnd	2.335u

	r_mt4 			CapPort4 	mt4_1	R_mt
	l_mt4 			mt4_1  	mt4_2	L_mt
	r_cap_esl4		mt4_2	mt4_3	1.f
	l_cap_esl4		mt4_3	mt4_4	1.f
	c_cap_4			mt4_4 	ref_gnd	2.335u
.ends siCap_EC2005P_4Part_RLx0p5

*** Ecap EC2006P, 39.3uF (R_mt, L_mt is per sub-cap)
.subckt siCap_EC2006P
+ capPort1 capPort2 capPort3 capPort4 ref_gnd R_mt=7.7u	L_mt=8.0p
	r_mt1 CapPort1 	mt1_1	R_mt
	l_mt1 mt1_1  	mt1_2	L_mt
	r_cap_esl1	mt1_2	mt1_3	6.m
	l_cap_esl1	mt1_3	mt1_4	1.1p
	c_cap_1	mt1_4 	ref_gnd	9.83u

	r_mt2 CapPort2 	mt2_1	R_mt
	l_mt2 mt2_1  	mt2_2	L_mt
	r_cap_esl2	mt2_2	mt2_3	6.m
	l_cap_esl2	mt2_3	mt2_4	1.1p
	c_cap_2	mt2_4 	ref_gnd	9.83u

	r_mt3 CapPort3 	mt3_1	R_mt
	l_mt3 mt3_1  	mt3_2	L_mt
	r_cap_esl3	mt3_2	mt3_3	6.m
	l_cap_esl3	mt3_3	mt3_4	1.1p
	c_cap_3	mt3_4 	ref_gnd	9.83u

	r_mt4 CapPort4 	mt4_1	R_mt
	l_mt4 mt4_1  	mt4_2	L_mt
	r_cap_esl4	mt4_2	mt4_3	6.m
	l_cap_esl4	mt4_3	mt4_4	1.1p
	c_cap_4	mt4_4 	ref_gnd	9.83u
.ends siCap_EC2006P

	***** define die model *****
.subckt model_die_lumped_nne_tile
	+ pin_bump ref_gnd C_die=100n R_die_1=1.25m R_die_2=RESMIN R_leak=0.84	pwl_file_in = str(pwl_file_quiet) delay = 0.

	R_die_1_ 	pin_bump	2	R_die_1
	R_die_2_	2		3	R_die_2
	C_die_		3		ref_gnd	C_die
	R_leak_		pin_bump	ref_gnd	R_leak
	IcurrSrc	pin_bump	ref_gnd	PWL pwlfile = str(pwl_file_in) td = delay    *** add 'R' if repeat
.ends

*** Samsung Ecaps
.inc /data/home/jiangongwei/work/PDN_core/hspice_inc/SCRLLC885MG6EGNNWT_Simple_DC0V_25degC_PC_V01.sp
.inc /data/home/jiangongwei/work/PDN_core/hspice_inc/SCRLLC106MG6EGNNWT_Simple_DC0V_25degC_PC_V01.sp

*** CPM w/o MIM
* .inc ./hspice_inc/cpm_nne_240724_modelOnly.sp		*** 4x8 parition
* .inc ./hspice_inc/cpm_nne_240523_modelOnly.spice

.inc /data/home/jiangongwei/work/PDN_core/hspice_inc/CPM_adsPowerModel_NNE_24x8_251117.sp		*** Andes 24x8 CPM die model , VERY slow due to size
.inc /data/home/jiangongwei/work/PDN_core/hspice_inc/cpm_nne_24x8_MOR_251120_v3_IdEM_1e_3.cir	*** reduced order model of "CPM_adsPowerModel_NNE_24x8_251117"

.inc /data/home/jiangongwei/work/PDN_core/hspice_inc/CPM_adsPowerModel_NNE_24x8_251117_Cx0p5.sp	*** 260302, Capacitance x 0.5 of CPM_adsPowerModel_NNE_24x8_251117.sp, VERY slow due to size
.inc /data/home/jiangongwei/work/PDN_core/hspice_inc/cpm_nne_24x8_MOR_Cx0p5_260302_IdEM_1e_4.cir  *** reduced order model of "CPM_adsPowerModel_NNE_24x8_251117_Cx0p5"

*** CPM w/ MIM included
* .inc ./hspice_inc/Chip_Power_Model_SubCircuit_NNE_w_MIM_240920_modelOnly.sp		*** 4x8, w/ MIM, 140um
* .inc ./hspice_inc/cpm_nne_w_MIM_240929_reduce_IdEM.cir	*** reduced model of "Chip_Power_Model_SubCircuit_NNE_w_MIM_240920_modelOnly"

* .inc ./hspice_inc/cpm_nne_4x2_240313.sp 			*** Andes 4x2 CPM model 240313
* .inc ./hspice_inc/cpm_nne_240426_Redu_IdEM.cir		*** 240426 CPM reduced model
* .inc ./hspice_inc/cpm_maual_appx_nne_4x2_240317.sp	*** jgwei 4x2 CPM manual mockup based on CPM

	***** define pkg model *****
	.inc ./hspice_inc/Z_plot_NNE_pkg_ReduceModel_4x8_32part_IdEM.cir		*** 250910， 32 partition pkg with 6x ecap ports
	* .inc ./hspice_inc/Z_plot_NNE_pkg_ReduceModel_4x8_32part_BGA40part_IdEM.cir		*** 251030, 32 partition pkg, PCB with 32+8 partition
	.inc /data/home/jiangongwei/work/PDN_core/hspice_inc/NNE_Mammoth_PKG_NNE_MAM_eCap_dCap_cutout_250715_jgwei_die24x8_BGA40part_251117_redu_IdEM.cir	*** 251118, 24x8 bump partition, BGA 40 part, MLCC embedded
	.inc /data/home/jiangongwei/work/PDN_core/hspice_inc/nne_only_mam_ecap_120624_1_1b_251123_odb_cut_NNE_bump24x8_BGA40part_IdEM.cir 		*** 251125, opt.1B option w/ 4x Ecap, 24x8 bump, 40 BGA , MLCC embedded
	.inc /data/home/jiangongwei/work/PDN_core/hspice_inc/nne_only_mam_ecap_120624_1_2b_251127_odb_opt2B_IdEM_v2.cir							*** 251128, opt.2B option w/ 5x Ecap, 24x8 bump, 40 BGA , MLCC embedded
	* .inc /data/home/jiangongwei/work/PDN_core/hspice_inc/NNE_only_MAM_ECAP_120624_1_1C_251205_2022R2_IdEM.cir								*** obsolete, 251205, opt.1C w/ 4x Ecap, 24x8 bump, 40 BGA , MLCC embedded
	.inc /data/home/jiangongwei/work/PDN_core/hspice_inc/NNE_only_MAM_ECAP_120624_1_1C_251205_2025R1_IdEM.cir								*** 251205, opt.1C w/ 4x Ecap, 24x8 bump, 40 BGA , MLCC embedded, SIwave 2025R1
	.inc /data/home/jiangongwei/work/PDN_core/hspice_inc/NNE_pkg_260101_Andes_2024_R2_HFSS_PI_modif_IdEM.cir								*** 260401, opt.1C w/ 4x Ecap, Andes siw, jgwei regrouping, HFSS PI solution

	.inc /data/home/jiangongwei/work/PDN_core/hspice_inc/NNE_only_MAM_ECAP_120624_1_1C_251205_2025R1_core400um_IdEM.cir						*** 251205, opt.1C w/ 4x Ecap, 24x8 bump, 40 BGA , MLCC embedded, SIwave 2025R1, 400um core
	.inc /data/home/jiangongwei/work/PDN_core/hspice_inc/NNE_only_MAM_ECAP_120624_1_1C_H65_251209_uVia65um_2025R1_IdEM.cir					*** 251205, opt.1C w/ 4x Ecap, 24x8 bump, 40 BGA , MLCC embedded, SIwave 2025R1, uVia 65um

	* .inc /data/home/jiangongwei/work/PDN_core/hspice_inc/NNE_only_MAM_ECAP_120624_1_1C_251205_2022R2_core400um_IdEM.cir						*** obsolete, 251205, opt.1C w/ 4x Ecap, 24x8 bump, 40 BGA , MLCC embedded, pkg core 400um
	.inc /data/home/jiangongwei/work/PDN_core/hspice_inc/NNE_only_MAM_ECAP_120624_1_1C_251205_2025R1_noMLCC_IdEM.cir						*** 251211, debug to remove MLCC
	.inc /data/home/jiangongwei/work/PDN_core/hspice_inc/NNE_only_MAM_ECAP_120624_1_1C_251205_2025R1_redu_DSC_Opt3_IdEM.cir					*** 260129, pkg DSC opt3, all MLCC removed
	.inc /data/home/jiangongwei/work/PDN_core/hspice_inc/NNE_only_MAM_ECAP_120624_1_1C_251205_2025R1_redu_DSC_Opt1_IdEM.cir					*** 260129, pkg DSC opt1, 20x 47nF removed
	.inc /data/home/jiangongwei/work/PDN_core/hspice_inc/NNE_only_MAM_ECAP_120624_1_1C_251205_2025R1_redu_DSC_Opt4_IdEM.cir					*** 260129, pkg DSC opt4, 20x 47nF + 5x 10uF removed
	.inc /data/home/jiangongwei/work/PDN_core/hspice_inc/mam_mcm_l12_bh9_ballv1p00_260604_1_v7_12x1mm_Ecap_redu_modif_IdEM.cir				*** 260606, mockup pkg w/ 12x 1x1mm Ecap

	.inc /data/home/jiangongwei/work/PDN_core/hspice_inc/sip_op2_ferric_072525_2_cut_NNE_die24x8_redu_IdEM.cir								*** 260701, 4x IVR at pkg back side, 3x Ecaps

	***** define PCB model *****
		* .inc ./hspice_inc/MAMMOTH_PCB_231031_3_NNE_LFmanip_IdEM.cir					*** 1101, version, SoC bulk caps added vias
		*.inc ./hspice_inc/ACM3_122323_nne_cut_manip_IdEM_s377p.cir					*** 231221 ACM3 PCB,   240126, accuracy not good btw 1~40MHz,  DO NOT USE
	.inc ./hspice_inc/ACM3_122323_nne_cut_reduce_v2_manip_s5p.cir				*** 231221 ACM3 PCB, reduced to 5 ports
		* .inc ./hspice_inc/ACM3_NEWLAYOUT_01_30_4_3uF_4Phase_half10uFCAPSrev3_manip_IdEM.cir		*** 240131 ACM3 PCB, Kavoos provided reduced PCB model, w/ 10uF, and 1uF caps; do NOT use due to LF noise near 500kHz
	.inc ./hspice_inc/ACM3_notoplayer_10_100uF_10_220uF_IdEM.cir				*** Kavoos 240216 ACM3, 10uF, w/ 20x bulk caps
	.inc ./hspice_inc/ACM3_notoplayer_no_10_100uF_10_220uF_IdEM.cir				*** Kavoos 240216 ACM3, 10uF, w/o 20x bulk caps
	.inc ./hspice_inc/ACM3_bulk_top_and_centerbottom_caps_IdEM.cir				*** Kavoos 240221 ACM3, only top side caps, bulk caps, 66 back side caps
	.inc ./hspice_inc/acm3_nne_240320_discrt_105C_IdEM.cir						*** jgwei 240314 ACM3, 105C,
	.inc ./hspice_inc/acm3_nne_240320_discrt_105C_No100uF_IdEM.cir				*** jgwei 240314 ACM3, 105C, no 100uF
		.inc ./hspice_inc/ACM3_105C_3_14_24_IdEM.cir								*** Kavoos 240314 ACM3 105C pcb
	.inc ./hspice_inc/acm3_nne_240320_discrt_105C_vf_no100uF_341x10uF_w_IVRports_manip_IdEM.cir	*** 240324 ACM3 105C, no 100uF, vertical feeding, 341x10uF caps
	.inc ./hspice_inc/ACM3_04172024_NNE_PDN_220uF_IdEM.cir						*** ACM3 240417, 10x220uF, 105C
	.inc ./hspice_inc/ACM3_05032024_NNE_PDN_jgwei_noBulk_Bga2Grp_s6p_IdEM.cir				*** ACM3 240503, only 10uF and 22uF, no bulkCap, originally for SIMPLIS sim, 2 BGA grps
	.inc ./hspice_inc/ACM3_05032024_NNE_PDN_jgwei_noBulk_Bga3Grp_IdEM.cir					*** ACM3 240503, only 10uF and 22uF, no bulkCap, originally for SIMPLIS sim, 3 BGA grps
	.inc ./hspice_inc/ACM3_05032024_NNE_PDN_BGAgrpX6_IdEM.cir								*** ACM3 240503, only 10uF and 22uF, no bulkCap, originally for SIMPLIS sim, 6 BGA grps
	.inc ./hspice_inc/ACM3_05032024_NNE_PDN_BGAgrpX6_trunc_25MHz_0x100uF_manip_IdEM.cir
	.inc ./hspice_inc/ACM3_05032024_NNE_PDN_BGAgrpX6_trunc_25MHz_0x100uF_0x22uF_manip_IdEM.cir

	.inc ./hspice_inc/ACM3_HF_20240730c_ebd_PSI_NNE_wAll_Caps_RLC.cir			*** 240903 Andes generated PCB model
	.inc ./hspice_inc/ACM3_Rev6_105C_240909_NNE_6xPhase_BGAx6_jgwei_swp2_IdEM.cir 	*** 240912, 6 phase layout, 105C
	.inc ./hspice_inc/ACM3_A0_241126_cut_NNE_6xPhase_BGAx6_baseline_IdEM.cir		*** 241126 ACM3 PCB,
	.inc ./hspice_inc/ACM3_A0_241126_cut_NNE_6xPhase_BGAx6_testcase1_IdEM.cir
	.inc ./hspice_inc/ACM3_A0_241126_cut_NNE_6xPhase_BGAx6_testcase1_kyo1uF_IdEM.cir
	.inc ./hspice_inc/ACM3_A0_241126_cut_NNE_6xPhase_BGAx6_testcase2_IdEM.cir
	.inc ./hspice_inc/ACM3_A0_241126_cut_NNE_6xPhase_BGAx6_testcase3_IdEM.cir
	.inc ./hspice_inc/ACM3_A0_241126_cut_NNE_6xPhase_BGAx6_testcase3_kyo1uF_IdEM.cir
	.inc ./hspice_inc/ACM3_A0_241126_cut_NNE_6xPhase_BGAx6_config3_IdEM.cir
	.inc ./hspice_inc/ACM3_A0_241126_cut_NNE_6xPhase_BGAx6_config4_IdEM.cir
	.inc ./hspice_inc/ACM3_A0_241126_cut_NNE_6xPhase_BGAx6_config6_IdEM.cir

	.inc ./hspice_inc/ACM3_A0_241126_cut_NNE_6xPhase_BGAx6_baseline_0x47uF_IdEM.cir
	.inc ./hspice_inc/ACM3_250223_8phases_BGAx6_discrt_IdEM.cir	*** 250222 8x PMIC phases, based on Poppy SIW
	.inc ./hspice_inc/SiVal_C_02192025_plug_ts_Order10_IdEM.cir			*** based on Poppy s14p
	.inc ./hspice_inc/ACM3_SiVal_250301_RevC2_discrt_8phases_BGAx6_jgwei_IdEM.cir	*** 250605 SiVal C board
	.inc ./hspice_inc/NNE_SiVal_revC_250808_6xBGA_8phases_s14p_IdEM.cir	*** 250825 SiVal C board from Poppy
	.inc ./hspice_inc/NNE_SiVal_revC_251028_BGA8x8_modif_IdEM_s48p.cir	*** 251030, SiVal C, BGA with 8x4 + 8 partition
	.inc /data/home/jiangongwei/work/PDN_core/hspice_inc/NNE_ACM3_C0_260108_redu_IdEM.cir	*** 260108 ACM3 C0, BGA w/ 40 grps

*************************************** End of User Input params **************

*************************************** cap model *****************************
.inc /data/home/jiangongwei/work/cap_models.hsp

*************************************** PMIC **********************************
*** ref_gnd def.
Vref_gnd 	ref_gnd		0	0.										*** normal gnd

.subckt PMIC_model
+ pin_out ref_gnd fdbk_node opt = 1 vdd_pmic = 0.75 Vdd_shift= 0.0 t_delay = 0.n pwl_volt_in = str(volt_src)
	*** opt 1/3 ideal voltage src
		.if (opt == 1)
			VshortPMIC	pin_out	ref_gnd	vdd_pmic
		.endif
	*** opt 2/3, add feedback
		.if (opt == 2)
			VshortPMIC_ref	pin_out_tmp	0 	vdd_pmic	*** ref contant voltage src

			VshortPMIC	pin_out	pin_tmp	vdd_pmic
			E_fdbk	    pin_tmp	ref_gnd VCVS DELAY pin_out_tmp fdbk_node  TD=0.n			*** VCVS to model feedback using low freq signal
		.endif
	*** opt 3/3 voltage src waveform w/ shift
		.if (opt == 3)
			Vpmic_wf     pin_out  pin_tmp  Vdd_shift					*** NOTE: shift waveform by constant voltage in V., use 0.0 if no shift
			Vpmic_wf_pwl pin_tmp  ref_gnd PWL pwlfile = str(pwl_volt_in)   td = t_delay
		.endif
	***
.ends

*** opt 1 ideal PMIC w/o remote sense feedback
.if ( 1 )
	xblk_PMIC pmic_pwr_raw ref_gnd pkg_bump_PA_ns_3_lf PMIC_model
	+ opt = 'PMIC_opt'  vdd_pmic = 'Vdd' 	Vdd_shift = 'Vdd_shift_fr_pwl'		t_delay = 0.u 	pwl_volt_in = str(volt_src)
.endif
*** opt 2 EMpower simplified IVR equivalent model 	(remember to disable PMIC bulk caps on PCB)
.if ( 0 )
	VempowerVS	pmicEMpwrNode1	ref_gnd	Vdd		*** can be switched to PMIC model
	LempowerVS1  pmicEMpwrNode1  pmicEMpwrNode2  	'0.027778n * 0.9091'
	RempowerVS1  pmicEMpwrNode2  pmic_pwr_raw			50.u
.endif

*** resistance of pmic output cap
r_pmic_l_eqv pmic_pwr_raw pmic_pwr induct_eqvlnt_r
			* L_induc pmic_pwr_raw pmic_pwr  32.n		*** experiment to include L (need to disable 'r_pmic_l_eqv' )

*** bulk caps added
	* xC_bulk_0 pmic_pwr ref_gnd	str(mlcc_22uF_0603)

											*** debug to short lump BGA/bumps
											* r_bga_short_0	bga_pcb_0  bga_pcb_1		1.n
											* r_bga_short_1	bga_pcb_0  bga_pcb_2		1.n
											* r_bga_short_2	bga_pcb_0  bga_pcb_3		1.n
											* r_bga_short_3	bga_pcb_0  bga_pcb_4		1.n
											* r_bga_short_4	bga_pcb_0  bga_pcb_5		1.n

											* r_bump_short_0 pkg_bump_PA_ns_3	pkg_bump_PA_ns_0 	1.n
											* r_bump_short_1 pkg_bump_PA_ns_3	pkg_bump_PA_ns_1 	1.n
											* r_bump_short_2 pkg_bump_PA_ns_3	pkg_bump_PA_ns_2 	1.n
											* r_bump_short_3 pkg_bump_PA_ns_3	pkg_bump_MA_ns_0 	1.n
											* r_bump_short_4 pkg_bump_PA_ns_3	pkg_bump_MA_ns_1 	1.n
											* r_bump_short_5 pkg_bump_PA_ns_3	pkg_bump_MA_ns_2 	1.n
											* r_bump_short_6 pkg_bump_PA_ns_3	pkg_bump_MA_ns_3 	1.n

														* *** debug to short pkg
														* r_bga_bump_short bga_pcb_0	pkg_bump_PA_ns_3	1.n

*** reduce num of grps to 8 for bump, 6 for BGA
* r_short_8xBumps_PA_0_conn_0_7	pkg_bump_ns_ew_0_7		pkg_bump_PA_ns_0	1.f
* r_short_8xBumps_PA_0_conn_1_7	pkg_bump_ns_ew_1_7		pkg_bump_PA_ns_0	1.f
* r_short_8xBumps_PA_0_conn_2_7	pkg_bump_ns_ew_2_7		pkg_bump_PA_ns_0	1.f
* r_short_8xBumps_PA_0_conn_3_7	pkg_bump_ns_ew_3_7		pkg_bump_PA_ns_0	1.f
* r_short_8xBumps_PA_0_conn_4_7	pkg_bump_ns_ew_4_7		pkg_bump_PA_ns_0	1.f
* r_short_8xBumps_PA_0_conn_5_7	pkg_bump_ns_ew_5_7		pkg_bump_PA_ns_0	1.f
* r_short_8xBumps_PA_0_conn_0_6	pkg_bump_ns_ew_0_6		pkg_bump_PA_ns_0	1.f
* r_short_8xBumps_PA_0_conn_1_6	pkg_bump_ns_ew_1_6		pkg_bump_PA_ns_0	1.f
* r_short_8xBumps_PA_0_conn_2_6	pkg_bump_ns_ew_2_6		pkg_bump_PA_ns_0	1.f
* r_short_8xBumps_PA_0_conn_3_6	pkg_bump_ns_ew_3_6		pkg_bump_PA_ns_0	1.f
* r_short_8xBumps_PA_0_conn_4_6	pkg_bump_ns_ew_4_6		pkg_bump_PA_ns_0	1.f
* r_short_8xBumps_PA_0_conn_5_6	pkg_bump_ns_ew_5_6		pkg_bump_PA_ns_0	1.f
* r_short_8xBumps_PA_0_conn_0_5	pkg_bump_ns_ew_0_5		pkg_bump_PA_ns_0	1.f
* r_short_8xBumps_PA_0_conn_1_5	pkg_bump_ns_ew_1_5		pkg_bump_PA_ns_0	1.f
* r_short_8xBumps_PA_0_conn_2_5	pkg_bump_ns_ew_2_5		pkg_bump_PA_ns_0	1.f
* r_short_8xBumps_PA_0_conn_3_5	pkg_bump_ns_ew_3_5		pkg_bump_PA_ns_0	1.f
* r_short_8xBumps_PA_0_conn_4_5	pkg_bump_ns_ew_4_5		pkg_bump_PA_ns_0	1.f
* r_short_8xBumps_PA_0_conn_5_5	pkg_bump_ns_ew_5_5		pkg_bump_PA_ns_0	1.f
* r_short_8xBumps_PA_0_conn_0_4	pkg_bump_ns_ew_0_4		pkg_bump_PA_ns_0	1.f
* r_short_8xBumps_PA_0_conn_1_4	pkg_bump_ns_ew_1_4		pkg_bump_PA_ns_0	1.f
* r_short_8xBumps_PA_0_conn_2_4	pkg_bump_ns_ew_2_4		pkg_bump_PA_ns_0	1.f
* r_short_8xBumps_PA_0_conn_3_4	pkg_bump_ns_ew_3_4		pkg_bump_PA_ns_0	1.f
* r_short_8xBumps_PA_0_conn_4_4	pkg_bump_ns_ew_4_4		pkg_bump_PA_ns_0	1.f
* r_short_8xBumps_PA_0_conn_5_4	pkg_bump_ns_ew_5_4		pkg_bump_PA_ns_0	1.f

* r_short_8xBumps_PA_1_conn_6_7	pkg_bump_ns_ew_6_7		pkg_bump_PA_ns_1	1.f
* r_short_8xBumps_PA_1_conn_7_7	pkg_bump_ns_ew_7_7		pkg_bump_PA_ns_1	1.f
* r_short_8xBumps_PA_1_conn_8_7	pkg_bump_ns_ew_8_7		pkg_bump_PA_ns_1	1.f
* r_short_8xBumps_PA_1_conn_9_7	pkg_bump_ns_ew_9_7		pkg_bump_PA_ns_1	1.f
* r_short_8xBumps_PA_1_conn_10_7	pkg_bump_ns_ew_10_7		pkg_bump_PA_ns_1	1.f
* r_short_8xBumps_PA_1_conn_11_7	pkg_bump_ns_ew_11_7		pkg_bump_PA_ns_1	1.f
* r_short_8xBumps_PA_1_conn_6_6	pkg_bump_ns_ew_6_6		pkg_bump_PA_ns_1	1.f
* r_short_8xBumps_PA_1_conn_7_6	pkg_bump_ns_ew_7_6		pkg_bump_PA_ns_1	1.f
* r_short_8xBumps_PA_1_conn_8_6	pkg_bump_ns_ew_8_6		pkg_bump_PA_ns_1	1.f
* r_short_8xBumps_PA_1_conn_9_6	pkg_bump_ns_ew_9_6		pkg_bump_PA_ns_1	1.f
* r_short_8xBumps_PA_1_conn_10_6	pkg_bump_ns_ew_10_6		pkg_bump_PA_ns_1	1.f
* r_short_8xBumps_PA_1_conn_11_6	pkg_bump_ns_ew_11_6		pkg_bump_PA_ns_1	1.f
* r_short_8xBumps_PA_1_conn_6_5	pkg_bump_ns_ew_6_5		pkg_bump_PA_ns_1	1.f
* r_short_8xBumps_PA_1_conn_7_5	pkg_bump_ns_ew_7_5		pkg_bump_PA_ns_1	1.f
* r_short_8xBumps_PA_1_conn_8_5	pkg_bump_ns_ew_8_5		pkg_bump_PA_ns_1	1.f
* r_short_8xBumps_PA_1_conn_9_5	pkg_bump_ns_ew_9_5		pkg_bump_PA_ns_1	1.f
* r_short_8xBumps_PA_1_conn_10_5	pkg_bump_ns_ew_10_5		pkg_bump_PA_ns_1	1.f
* r_short_8xBumps_PA_1_conn_11_5	pkg_bump_ns_ew_11_5		pkg_bump_PA_ns_1	1.f
* r_short_8xBumps_PA_1_conn_6_4	pkg_bump_ns_ew_6_4		pkg_bump_PA_ns_1	1.f
* r_short_8xBumps_PA_1_conn_7_4	pkg_bump_ns_ew_7_4		pkg_bump_PA_ns_1	1.f
* r_short_8xBumps_PA_1_conn_8_4	pkg_bump_ns_ew_8_4		pkg_bump_PA_ns_1	1.f
* r_short_8xBumps_PA_1_conn_9_4	pkg_bump_ns_ew_9_4		pkg_bump_PA_ns_1	1.f
* r_short_8xBumps_PA_1_conn_10_4	pkg_bump_ns_ew_10_4		pkg_bump_PA_ns_1	1.f
* r_short_8xBumps_PA_1_conn_11_4	pkg_bump_ns_ew_11_4		pkg_bump_PA_ns_1	1.f

* r_short_8xBumps_PA_2_conn_12_7	pkg_bump_ns_ew_12_7		pkg_bump_PA_ns_2	1.f
* r_short_8xBumps_PA_2_conn_13_7	pkg_bump_ns_ew_13_7		pkg_bump_PA_ns_2	1.f
* r_short_8xBumps_PA_2_conn_14_7	pkg_bump_ns_ew_14_7		pkg_bump_PA_ns_2	1.f
* r_short_8xBumps_PA_2_conn_15_7	pkg_bump_ns_ew_15_7		pkg_bump_PA_ns_2	1.f
* r_short_8xBumps_PA_2_conn_16_7	pkg_bump_ns_ew_16_7		pkg_bump_PA_ns_2	1.f
* r_short_8xBumps_PA_2_conn_17_7	pkg_bump_ns_ew_17_7		pkg_bump_PA_ns_2	1.f
* r_short_8xBumps_PA_2_conn_12_6	pkg_bump_ns_ew_12_6		pkg_bump_PA_ns_2	1.f
* r_short_8xBumps_PA_2_conn_13_6	pkg_bump_ns_ew_13_6		pkg_bump_PA_ns_2	1.f
* r_short_8xBumps_PA_2_conn_14_6	pkg_bump_ns_ew_14_6		pkg_bump_PA_ns_2	1.f
* r_short_8xBumps_PA_2_conn_15_6	pkg_bump_ns_ew_15_6		pkg_bump_PA_ns_2	1.f
* r_short_8xBumps_PA_2_conn_16_6	pkg_bump_ns_ew_16_6		pkg_bump_PA_ns_2	1.f
* r_short_8xBumps_PA_2_conn_17_6	pkg_bump_ns_ew_17_6		pkg_bump_PA_ns_2	1.f
* r_short_8xBumps_PA_2_conn_12_5	pkg_bump_ns_ew_12_5		pkg_bump_PA_ns_2	1.f
* r_short_8xBumps_PA_2_conn_13_5	pkg_bump_ns_ew_13_5		pkg_bump_PA_ns_2	1.f
* r_short_8xBumps_PA_2_conn_14_5	pkg_bump_ns_ew_14_5		pkg_bump_PA_ns_2	1.f
* r_short_8xBumps_PA_2_conn_15_5	pkg_bump_ns_ew_15_5		pkg_bump_PA_ns_2	1.f
* r_short_8xBumps_PA_2_conn_16_5	pkg_bump_ns_ew_16_5		pkg_bump_PA_ns_2	1.f
* r_short_8xBumps_PA_2_conn_17_5	pkg_bump_ns_ew_17_5		pkg_bump_PA_ns_2	1.f
* r_short_8xBumps_PA_2_conn_12_4	pkg_bump_ns_ew_12_4		pkg_bump_PA_ns_2	1.f
* r_short_8xBumps_PA_2_conn_13_4	pkg_bump_ns_ew_13_4		pkg_bump_PA_ns_2	1.f
* r_short_8xBumps_PA_2_conn_14_4	pkg_bump_ns_ew_14_4		pkg_bump_PA_ns_2	1.f
* r_short_8xBumps_PA_2_conn_15_4	pkg_bump_ns_ew_15_4		pkg_bump_PA_ns_2	1.f
* r_short_8xBumps_PA_2_conn_16_4	pkg_bump_ns_ew_16_4		pkg_bump_PA_ns_2	1.f
* r_short_8xBumps_PA_2_conn_17_4	pkg_bump_ns_ew_17_4		pkg_bump_PA_ns_2	1.f

* r_short_8xBumps_PA_3_conn_18_7	pkg_bump_ns_ew_18_7		pkg_bump_PA_ns_3	1.f
* r_short_8xBumps_PA_3_conn_19_7	pkg_bump_ns_ew_19_7		pkg_bump_PA_ns_3	1.f
* r_short_8xBumps_PA_3_conn_20_7	pkg_bump_ns_ew_20_7		pkg_bump_PA_ns_3	1.f
* r_short_8xBumps_PA_3_conn_21_7	pkg_bump_ns_ew_21_7		pkg_bump_PA_ns_3	1.f
* r_short_8xBumps_PA_3_conn_22_7	pkg_bump_ns_ew_22_7		pkg_bump_PA_ns_3	1.f
* r_short_8xBumps_PA_3_conn_23_7	pkg_bump_ns_ew_23_7		pkg_bump_PA_ns_3	1.f
* r_short_8xBumps_PA_3_conn_18_6	pkg_bump_ns_ew_18_6		pkg_bump_PA_ns_3	1.f
* r_short_8xBumps_PA_3_conn_19_6	pkg_bump_ns_ew_19_6		pkg_bump_PA_ns_3	1.f
* r_short_8xBumps_PA_3_conn_20_6	pkg_bump_ns_ew_20_6		pkg_bump_PA_ns_3	1.f
* r_short_8xBumps_PA_3_conn_21_6	pkg_bump_ns_ew_21_6		pkg_bump_PA_ns_3	1.f
* r_short_8xBumps_PA_3_conn_22_6	pkg_bump_ns_ew_22_6		pkg_bump_PA_ns_3	1.f
* r_short_8xBumps_PA_3_conn_23_6	pkg_bump_ns_ew_23_6		pkg_bump_PA_ns_3	1.f
* r_short_8xBumps_PA_3_conn_18_5	pkg_bump_ns_ew_18_5		pkg_bump_PA_ns_3	1.f
* r_short_8xBumps_PA_3_conn_19_5	pkg_bump_ns_ew_19_5		pkg_bump_PA_ns_3	1.f
* r_short_8xBumps_PA_3_conn_20_5	pkg_bump_ns_ew_20_5		pkg_bump_PA_ns_3	1.f
* r_short_8xBumps_PA_3_conn_21_5	pkg_bump_ns_ew_21_5		pkg_bump_PA_ns_3	1.f
* r_short_8xBumps_PA_3_conn_22_5	pkg_bump_ns_ew_22_5		pkg_bump_PA_ns_3	1.f
* r_short_8xBumps_PA_3_conn_23_5	pkg_bump_ns_ew_23_5		pkg_bump_PA_ns_3	1.f
* r_short_8xBumps_PA_3_conn_18_4	pkg_bump_ns_ew_18_4		pkg_bump_PA_ns_3	1.f
* r_short_8xBumps_PA_3_conn_19_4	pkg_bump_ns_ew_19_4		pkg_bump_PA_ns_3	1.f
* r_short_8xBumps_PA_3_conn_20_4	pkg_bump_ns_ew_20_4		pkg_bump_PA_ns_3	1.f
* r_short_8xBumps_PA_3_conn_21_4	pkg_bump_ns_ew_21_4		pkg_bump_PA_ns_3	1.f
* r_short_8xBumps_PA_3_conn_22_4	pkg_bump_ns_ew_22_4		pkg_bump_PA_ns_3	1.f
* r_short_8xBumps_PA_3_conn_23_4	pkg_bump_ns_ew_23_4		pkg_bump_PA_ns_3	1.f

* r_short_8xBumps_MA_0_conn_0_3	pkg_bump_ns_ew_0_3		pkg_bump_MA_ns_0	1.f
* r_short_8xBumps_MA_0_conn_1_3	pkg_bump_ns_ew_1_3		pkg_bump_MA_ns_0	1.f
* r_short_8xBumps_MA_0_conn_2_3	pkg_bump_ns_ew_2_3		pkg_bump_MA_ns_0	1.f
* r_short_8xBumps_MA_0_conn_3_3	pkg_bump_ns_ew_3_3		pkg_bump_MA_ns_0	1.f
* r_short_8xBumps_MA_0_conn_4_3	pkg_bump_ns_ew_4_3		pkg_bump_MA_ns_0	1.f
* r_short_8xBumps_MA_0_conn_5_3	pkg_bump_ns_ew_5_3		pkg_bump_MA_ns_0	1.f
* r_short_8xBumps_MA_0_conn_0_2	pkg_bump_ns_ew_0_2		pkg_bump_MA_ns_0	1.f
* r_short_8xBumps_MA_0_conn_1_2	pkg_bump_ns_ew_1_2		pkg_bump_MA_ns_0	1.f
* r_short_8xBumps_MA_0_conn_2_2	pkg_bump_ns_ew_2_2		pkg_bump_MA_ns_0	1.f
* r_short_8xBumps_MA_0_conn_3_2	pkg_bump_ns_ew_3_2		pkg_bump_MA_ns_0	1.f
* r_short_8xBumps_MA_0_conn_4_2	pkg_bump_ns_ew_4_2		pkg_bump_MA_ns_0	1.f
* r_short_8xBumps_MA_0_conn_5_2	pkg_bump_ns_ew_5_2		pkg_bump_MA_ns_0	1.f
* r_short_8xBumps_MA_0_conn_0_1	pkg_bump_ns_ew_0_1		pkg_bump_MA_ns_0	1.f
* r_short_8xBumps_MA_0_conn_1_1	pkg_bump_ns_ew_1_1		pkg_bump_MA_ns_0	1.f
* r_short_8xBumps_MA_0_conn_2_1	pkg_bump_ns_ew_2_1		pkg_bump_MA_ns_0	1.f
* r_short_8xBumps_MA_0_conn_3_1	pkg_bump_ns_ew_3_1		pkg_bump_MA_ns_0	1.f
* r_short_8xBumps_MA_0_conn_4_1	pkg_bump_ns_ew_4_1		pkg_bump_MA_ns_0	1.f
* r_short_8xBumps_MA_0_conn_5_1	pkg_bump_ns_ew_5_1		pkg_bump_MA_ns_0	1.f
* r_short_8xBumps_MA_0_conn_0_0	pkg_bump_ns_ew_0_0		pkg_bump_MA_ns_0	1.f
* r_short_8xBumps_MA_0_conn_1_0	pkg_bump_ns_ew_1_0		pkg_bump_MA_ns_0	1.f
* r_short_8xBumps_MA_0_conn_2_0	pkg_bump_ns_ew_2_0		pkg_bump_MA_ns_0	1.f
* r_short_8xBumps_MA_0_conn_3_0	pkg_bump_ns_ew_3_0		pkg_bump_MA_ns_0	1.f
* r_short_8xBumps_MA_0_conn_4_0	pkg_bump_ns_ew_4_0		pkg_bump_MA_ns_0	1.f
* r_short_8xBumps_MA_0_conn_5_0	pkg_bump_ns_ew_5_0		pkg_bump_MA_ns_0	1.f

* r_short_8xBumps_MA_1_conn_6_3	 pkg_bump_ns_ew_6_3		pkg_bump_MA_ns_1	1.f
* r_short_8xBumps_MA_1_conn_7_3	 pkg_bump_ns_ew_7_3		pkg_bump_MA_ns_1	1.f
* r_short_8xBumps_MA_1_conn_8_3	 pkg_bump_ns_ew_8_3		pkg_bump_MA_ns_1	1.f
* r_short_8xBumps_MA_1_conn_9_3	 pkg_bump_ns_ew_9_3		pkg_bump_MA_ns_1	1.f
* r_short_8xBumps_MA_1_conn_10_3	pkg_bump_ns_ew_10_3		pkg_bump_MA_ns_1	1.f
* r_short_8xBumps_MA_1_conn_11_3	pkg_bump_ns_ew_11_3		pkg_bump_MA_ns_1	1.f
* r_short_8xBumps_MA_1_conn_6_2	 pkg_bump_ns_ew_6_2		pkg_bump_MA_ns_1	1.f
* r_short_8xBumps_MA_1_conn_7_2	 pkg_bump_ns_ew_7_2		pkg_bump_MA_ns_1	1.f
* r_short_8xBumps_MA_1_conn_8_2	 pkg_bump_ns_ew_8_2		pkg_bump_MA_ns_1	1.f
* r_short_8xBumps_MA_1_conn_9_2	 pkg_bump_ns_ew_9_2		pkg_bump_MA_ns_1	1.f
* r_short_8xBumps_MA_1_conn_10_2	pkg_bump_ns_ew_10_2		pkg_bump_MA_ns_1	1.f
* r_short_8xBumps_MA_1_conn_11_2	pkg_bump_ns_ew_11_2		pkg_bump_MA_ns_1	1.f
* r_short_8xBumps_MA_1_conn_6_1	 pkg_bump_ns_ew_6_1		pkg_bump_MA_ns_1	1.f
* r_short_8xBumps_MA_1_conn_7_1	 pkg_bump_ns_ew_7_1		pkg_bump_MA_ns_1	1.f
* r_short_8xBumps_MA_1_conn_8_1	 pkg_bump_ns_ew_8_1		pkg_bump_MA_ns_1	1.f
* r_short_8xBumps_MA_1_conn_9_1	 pkg_bump_ns_ew_9_1		pkg_bump_MA_ns_1	1.f
* r_short_8xBumps_MA_1_conn_10_1	pkg_bump_ns_ew_10_1		pkg_bump_MA_ns_1	1.f
* r_short_8xBumps_MA_1_conn_11_1	pkg_bump_ns_ew_11_1		pkg_bump_MA_ns_1	1.f
* r_short_8xBumps_MA_1_conn_6_0	 pkg_bump_ns_ew_6_0		pkg_bump_MA_ns_1	1.f
* r_short_8xBumps_MA_1_conn_7_0	 pkg_bump_ns_ew_7_0		pkg_bump_MA_ns_1	1.f
* r_short_8xBumps_MA_1_conn_8_0	 pkg_bump_ns_ew_8_0		pkg_bump_MA_ns_1	1.f
* r_short_8xBumps_MA_1_conn_9_0	 pkg_bump_ns_ew_9_0		pkg_bump_MA_ns_1	1.f
* r_short_8xBumps_MA_1_conn_10_0	pkg_bump_ns_ew_10_0		pkg_bump_MA_ns_1	1.f
* r_short_8xBumps_MA_1_conn_11_0	pkg_bump_ns_ew_11_0		pkg_bump_MA_ns_1	1.f

* r_short_8xBumps_MA_2_conn_12_3	pkg_bump_ns_ew_12_3		pkg_bump_MA_ns_2	1.f
* r_short_8xBumps_MA_2_conn_13_3	pkg_bump_ns_ew_13_3		pkg_bump_MA_ns_2	1.f
* r_short_8xBumps_MA_2_conn_14_3	pkg_bump_ns_ew_14_3		pkg_bump_MA_ns_2	1.f
* r_short_8xBumps_MA_2_conn_15_3	pkg_bump_ns_ew_15_3		pkg_bump_MA_ns_2	1.f
* r_short_8xBumps_MA_2_conn_16_3	pkg_bump_ns_ew_16_3		pkg_bump_MA_ns_2	1.f
* r_short_8xBumps_MA_2_conn_17_3	pkg_bump_ns_ew_17_3		pkg_bump_MA_ns_2	1.f
* r_short_8xBumps_MA_2_conn_12_2	pkg_bump_ns_ew_12_2		pkg_bump_MA_ns_2	1.f
* r_short_8xBumps_MA_2_conn_13_2	pkg_bump_ns_ew_13_2		pkg_bump_MA_ns_2	1.f
* r_short_8xBumps_MA_2_conn_14_2	pkg_bump_ns_ew_14_2		pkg_bump_MA_ns_2	1.f
* r_short_8xBumps_MA_2_conn_15_2	pkg_bump_ns_ew_15_2		pkg_bump_MA_ns_2	1.f
* r_short_8xBumps_MA_2_conn_16_2	pkg_bump_ns_ew_16_2		pkg_bump_MA_ns_2	1.f
* r_short_8xBumps_MA_2_conn_17_2	pkg_bump_ns_ew_17_2		pkg_bump_MA_ns_2	1.f
* r_short_8xBumps_MA_2_conn_12_1	pkg_bump_ns_ew_12_1		pkg_bump_MA_ns_2	1.f
* r_short_8xBumps_MA_2_conn_13_1	pkg_bump_ns_ew_13_1		pkg_bump_MA_ns_2	1.f
* r_short_8xBumps_MA_2_conn_14_1	pkg_bump_ns_ew_14_1		pkg_bump_MA_ns_2	1.f
* r_short_8xBumps_MA_2_conn_15_1	pkg_bump_ns_ew_15_1		pkg_bump_MA_ns_2	1.f
* r_short_8xBumps_MA_2_conn_16_1	pkg_bump_ns_ew_16_1		pkg_bump_MA_ns_2	1.f
* r_short_8xBumps_MA_2_conn_17_1	pkg_bump_ns_ew_17_1		pkg_bump_MA_ns_2	1.f
* r_short_8xBumps_MA_2_conn_12_0	pkg_bump_ns_ew_12_0		pkg_bump_MA_ns_2	1.f
* r_short_8xBumps_MA_2_conn_13_0	pkg_bump_ns_ew_13_0		pkg_bump_MA_ns_2	1.f
* r_short_8xBumps_MA_2_conn_14_0	pkg_bump_ns_ew_14_0		pkg_bump_MA_ns_2	1.f
* r_short_8xBumps_MA_2_conn_15_0	pkg_bump_ns_ew_15_0		pkg_bump_MA_ns_2	1.f
* r_short_8xBumps_MA_2_conn_16_0	pkg_bump_ns_ew_16_0		pkg_bump_MA_ns_2	1.f
* r_short_8xBumps_MA_2_conn_17_0	pkg_bump_ns_ew_17_0		pkg_bump_MA_ns_2	1.f

* r_short_8xBumps_MA_3_conn_18_3	pkg_bump_ns_ew_18_3		pkg_bump_MA_ns_3	1.f
* r_short_8xBumps_MA_3_conn_19_3	pkg_bump_ns_ew_19_3		pkg_bump_MA_ns_3	1.f
* r_short_8xBumps_MA_3_conn_20_3	pkg_bump_ns_ew_20_3		pkg_bump_MA_ns_3	1.f
* r_short_8xBumps_MA_3_conn_21_3	pkg_bump_ns_ew_21_3		pkg_bump_MA_ns_3	1.f
* r_short_8xBumps_MA_3_conn_22_3	pkg_bump_ns_ew_22_3		pkg_bump_MA_ns_3	1.f
* r_short_8xBumps_MA_3_conn_23_3	pkg_bump_ns_ew_23_3		pkg_bump_MA_ns_3	1.f
* r_short_8xBumps_MA_3_conn_18_2	pkg_bump_ns_ew_18_2		pkg_bump_MA_ns_3	1.f
* r_short_8xBumps_MA_3_conn_19_2	pkg_bump_ns_ew_19_2		pkg_bump_MA_ns_3	1.f
* r_short_8xBumps_MA_3_conn_20_2	pkg_bump_ns_ew_20_2		pkg_bump_MA_ns_3	1.f
* r_short_8xBumps_MA_3_conn_21_2	pkg_bump_ns_ew_21_2		pkg_bump_MA_ns_3	1.f
* r_short_8xBumps_MA_3_conn_22_2	pkg_bump_ns_ew_22_2		pkg_bump_MA_ns_3	1.f
* r_short_8xBumps_MA_3_conn_23_2	pkg_bump_ns_ew_23_2		pkg_bump_MA_ns_3	1.f
* r_short_8xBumps_MA_3_conn_18_1	pkg_bump_ns_ew_18_1		pkg_bump_MA_ns_3	1.f
* r_short_8xBumps_MA_3_conn_19_1	pkg_bump_ns_ew_19_1		pkg_bump_MA_ns_3	1.f
* r_short_8xBumps_MA_3_conn_20_1	pkg_bump_ns_ew_20_1		pkg_bump_MA_ns_3	1.f
* r_short_8xBumps_MA_3_conn_21_1	pkg_bump_ns_ew_21_1		pkg_bump_MA_ns_3	1.f
* r_short_8xBumps_MA_3_conn_22_1	pkg_bump_ns_ew_22_1		pkg_bump_MA_ns_3	1.f
* r_short_8xBumps_MA_3_conn_23_1	pkg_bump_ns_ew_23_1		pkg_bump_MA_ns_3	1.f
* r_short_8xBumps_MA_3_conn_18_0	pkg_bump_ns_ew_18_0		pkg_bump_MA_ns_3	1.f
* r_short_8xBumps_MA_3_conn_19_0	pkg_bump_ns_ew_19_0		pkg_bump_MA_ns_3	1.f
* r_short_8xBumps_MA_3_conn_20_0	pkg_bump_ns_ew_20_0		pkg_bump_MA_ns_3	1.f
* r_short_8xBumps_MA_3_conn_21_0	pkg_bump_ns_ew_21_0		pkg_bump_MA_ns_3	1.f
* r_short_8xBumps_MA_3_conn_22_0	pkg_bump_ns_ew_22_0		pkg_bump_MA_ns_3	1.f
* r_short_8xBumps_MA_3_conn_23_0	pkg_bump_ns_ew_23_0		pkg_bump_MA_ns_3	1.f

* r_short_6xBGA_bga_pcb_0_conn_3_7		bga_3_7		bga_pcb_0		1.f
* r_short_6xBGA_bga_pcb_0_conn_3_6		bga_3_6		bga_pcb_0		1.f
* r_short_6xBGA_bga_pcb_0_conn_3_5		bga_3_5		bga_pcb_0		1.f
* r_short_6xBGA_bga_pcb_0_conn_3_4		bga_3_4		bga_pcb_0		1.f
* r_short_6xBGA_bga_pcb_0_conn_3_3		bga_3_3		bga_pcb_0		1.f
* r_short_6xBGA_bga_pcb_0_conn_3_2		bga_3_2		bga_pcb_0		1.f
* r_short_6xBGA_bga_pcb_0_conn_3_1		bga_3_1		bga_pcb_0		1.f
* r_short_6xBGA_bga_pcb_0_conn_3_0		bga_3_0		bga_pcb_0		1.f

* r_short_6xBGA_bga_pcb_1_conn_2_7		bga_2_7		bga_pcb_1		1.f
* r_short_6xBGA_bga_pcb_1_conn_2_6		bga_2_6		bga_pcb_1		1.f
* r_short_6xBGA_bga_pcb_1_conn_2_5		bga_2_5		bga_pcb_1		1.f
* r_short_6xBGA_bga_pcb_1_conn_2_4		bga_2_4		bga_pcb_1		1.f
* r_short_6xBGA_bga_pcb_1_conn_2_3		bga_2_3		bga_pcb_1		1.f
* r_short_6xBGA_bga_pcb_1_conn_2_2		bga_2_2		bga_pcb_1		1.f
* r_short_6xBGA_bga_pcb_1_conn_2_1		bga_2_1		bga_pcb_1		1.f
* r_short_6xBGA_bga_pcb_1_conn_2_0		bga_2_0		bga_pcb_1		1.f

* r_short_6xBGA_bga_pcb_2_conn_1_7		bga_1_7		bga_pcb_2		1.f
* r_short_6xBGA_bga_pcb_2_conn_1_6		bga_1_6		bga_pcb_2		1.f
* r_short_6xBGA_bga_pcb_2_conn_1_5		bga_1_5		bga_pcb_2		1.f
* r_short_6xBGA_bga_pcb_2_conn_1_4		bga_1_4		bga_pcb_2		1.f
* r_short_6xBGA_bga_pcb_2_conn_1_3		bga_1_3		bga_pcb_2		1.f
* r_short_6xBGA_bga_pcb_2_conn_1_2		bga_1_2		bga_pcb_2		1.f
* r_short_6xBGA_bga_pcb_2_conn_1_1		bga_1_1		bga_pcb_2		1.f
* r_short_6xBGA_bga_pcb_2_conn_1_0		bga_1_0		bga_pcb_2		1.f

* r_short_6xBGA_bga_pcb_3_conn_0_7		bga_0_7		bga_pcb_3		1.f
* r_short_6xBGA_bga_pcb_3_conn_0_6		bga_0_6		bga_pcb_3		1.f
* r_short_6xBGA_bga_pcb_3_conn_0_5		bga_0_5		bga_pcb_3		1.f
* r_short_6xBGA_bga_pcb_3_conn_0_4		bga_0_4		bga_pcb_3		1.f
* r_short_6xBGA_bga_pcb_3_conn_0_3		bga_0_3		bga_pcb_3		1.f
* r_short_6xBGA_bga_pcb_3_conn_0_2		bga_0_2		bga_pcb_3		1.f
* r_short_6xBGA_bga_pcb_3_conn_0_1		bga_0_1		bga_pcb_3		1.f
* r_short_6xBGA_bga_pcb_3_conn_0_0		bga_0_0		bga_pcb_3		1.f

* r_short_6xBGA_bga_pcb_4_conn_0_1 	bga_OUT_0_1		bga_pcb_4 	1.f
* r_short_6xBGA_bga_pcb_4_conn_0_2 	bga_OUT_0_2		bga_pcb_4 	1.f
* r_short_6xBGA_bga_pcb_4_conn_1_1 	bga_OUT_1_1		bga_pcb_4 	1.f
* r_short_6xBGA_bga_pcb_4_conn_1_2 	bga_OUT_1_2		bga_pcb_4 	1.f

* r_short_6xBGA_bga_pcb_5_conn_0_3 	bga_OUT_0_3		bga_pcb_5 	1.f
* r_short_6xBGA_bga_pcb_5_conn_0_4 	bga_OUT_0_4		bga_pcb_5 	1.f
* r_short_6xBGA_bga_pcb_5_conn_1_3 	bga_OUT_1_3		bga_pcb_5 	1.f
* r_short_6xBGA_bga_pcb_5_conn_1_4 	bga_OUT_1_4		bga_pcb_5 	1.f

***END  reduce num of grps to 8 for bump, 6 for BGA

							*** debug to short all bumps together
							* r_short_bump_0_1     pkg_bump_ns_ew_0_1	 pkg_bump_ns_ew_0_0    1.f
							* r_short_bump_0_2     pkg_bump_ns_ew_0_2    pkg_bump_ns_ew_0_0    1.f
							* r_short_bump_0_3     pkg_bump_ns_ew_0_3    pkg_bump_ns_ew_0_0    1.f
							* r_short_bump_0_4     pkg_bump_ns_ew_0_4    pkg_bump_ns_ew_0_0    1.f
							* r_short_bump_0_5     pkg_bump_ns_ew_0_5    pkg_bump_ns_ew_0_0    1.f
							* r_short_bump_0_6     pkg_bump_ns_ew_0_6    pkg_bump_ns_ew_0_0    1.f
							* r_short_bump_0_7     pkg_bump_ns_ew_0_7    pkg_bump_ns_ew_0_0    1.f
							* r_short_bump_1_0     pkg_bump_ns_ew_1_0    pkg_bump_ns_ew_0_0    1.f
							* r_short_bump_1_1     pkg_bump_ns_ew_1_1    pkg_bump_ns_ew_0_0    1.f
							* r_short_bump_1_2     pkg_bump_ns_ew_1_2    pkg_bump_ns_ew_0_0    1.f
							* r_short_bump_1_3     pkg_bump_ns_ew_1_3    pkg_bump_ns_ew_0_0    1.f
							* r_short_bump_1_4     pkg_bump_ns_ew_1_4    pkg_bump_ns_ew_0_0    1.f
							* r_short_bump_1_5     pkg_bump_ns_ew_1_5    pkg_bump_ns_ew_0_0    1.f
							* r_short_bump_1_6     pkg_bump_ns_ew_1_6    pkg_bump_ns_ew_0_0    1.f
							* r_short_bump_1_7     pkg_bump_ns_ew_1_7    pkg_bump_ns_ew_0_0    1.f
							* r_short_bump_2_0     pkg_bump_ns_ew_2_0    pkg_bump_ns_ew_0_0    1.f
							* r_short_bump_2_1     pkg_bump_ns_ew_2_1    pkg_bump_ns_ew_0_0    1.f
							* r_short_bump_2_2     pkg_bump_ns_ew_2_2    pkg_bump_ns_ew_0_0    1.f
							* r_short_bump_2_3     pkg_bump_ns_ew_2_3    pkg_bump_ns_ew_0_0    1.f
							* r_short_bump_2_4     pkg_bump_ns_ew_2_4    pkg_bump_ns_ew_0_0    1.f
							* r_short_bump_2_5     pkg_bump_ns_ew_2_5    pkg_bump_ns_ew_0_0    1.f
							* r_short_bump_2_6     pkg_bump_ns_ew_2_6    pkg_bump_ns_ew_0_0    1.f
							* r_short_bump_2_7     pkg_bump_ns_ew_2_7    pkg_bump_ns_ew_0_0    1.f
							* r_short_bump_3_0     pkg_bump_ns_ew_3_0    pkg_bump_ns_ew_0_0    1.f
							* r_short_bump_3_1     pkg_bump_ns_ew_3_1    pkg_bump_ns_ew_0_0    1.f
							* r_short_bump_3_2     pkg_bump_ns_ew_3_2    pkg_bump_ns_ew_0_0    1.f
							* r_short_bump_3_3     pkg_bump_ns_ew_3_3    pkg_bump_ns_ew_0_0    1.f
							* r_short_bump_3_4     pkg_bump_ns_ew_3_4    pkg_bump_ns_ew_0_0    1.f
							* r_short_bump_3_5     pkg_bump_ns_ew_3_5    pkg_bump_ns_ew_0_0    1.f
							* r_short_bump_3_6     pkg_bump_ns_ew_3_6    pkg_bump_ns_ew_0_0    1.f
							* r_short_bump_3_7     pkg_bump_ns_ew_3_7    pkg_bump_ns_ew_0_0    1.f
							* r_short_bump_4_0     pkg_bump_ns_ew_4_0    pkg_bump_ns_ew_0_0    1.f
							* r_short_bump_4_1     pkg_bump_ns_ew_4_1    pkg_bump_ns_ew_0_0    1.f
							* r_short_bump_4_2     pkg_bump_ns_ew_4_2    pkg_bump_ns_ew_0_0    1.f
							* r_short_bump_4_3     pkg_bump_ns_ew_4_3    pkg_bump_ns_ew_0_0    1.f
							* r_short_bump_4_4     pkg_bump_ns_ew_4_4    pkg_bump_ns_ew_0_0    1.f
							* r_short_bump_4_5     pkg_bump_ns_ew_4_5    pkg_bump_ns_ew_0_0    1.f
							* r_short_bump_4_6     pkg_bump_ns_ew_4_6    pkg_bump_ns_ew_0_0    1.f
							* r_short_bump_4_7     pkg_bump_ns_ew_4_7    pkg_bump_ns_ew_0_0    1.f
							* r_short_bump_5_0     pkg_bump_ns_ew_5_0    pkg_bump_ns_ew_0_0    1.f
							* r_short_bump_5_1     pkg_bump_ns_ew_5_1    pkg_bump_ns_ew_0_0    1.f
							* r_short_bump_5_2     pkg_bump_ns_ew_5_2    pkg_bump_ns_ew_0_0    1.f
							* r_short_bump_5_3     pkg_bump_ns_ew_5_3    pkg_bump_ns_ew_0_0    1.f
							* r_short_bump_5_4     pkg_bump_ns_ew_5_4    pkg_bump_ns_ew_0_0    1.f
							* r_short_bump_5_5     pkg_bump_ns_ew_5_5    pkg_bump_ns_ew_0_0    1.f
							* r_short_bump_5_6     pkg_bump_ns_ew_5_6    pkg_bump_ns_ew_0_0    1.f
							* r_short_bump_5_7     pkg_bump_ns_ew_5_7    pkg_bump_ns_ew_0_0    1.f
							* r_short_bump_6_0     pkg_bump_ns_ew_6_0    pkg_bump_ns_ew_0_0    1.f
							* r_short_bump_6_1     pkg_bump_ns_ew_6_1    pkg_bump_ns_ew_0_0    1.f
							* r_short_bump_6_2     pkg_bump_ns_ew_6_2    pkg_bump_ns_ew_0_0    1.f
							* r_short_bump_6_3     pkg_bump_ns_ew_6_3    pkg_bump_ns_ew_0_0    1.f
							* r_short_bump_6_4     pkg_bump_ns_ew_6_4    pkg_bump_ns_ew_0_0    1.f
							* r_short_bump_6_5     pkg_bump_ns_ew_6_5    pkg_bump_ns_ew_0_0    1.f
							* r_short_bump_6_6     pkg_bump_ns_ew_6_6    pkg_bump_ns_ew_0_0    1.f
							* r_short_bump_6_7     pkg_bump_ns_ew_6_7    pkg_bump_ns_ew_0_0    1.f
							* r_short_bump_7_0     pkg_bump_ns_ew_7_0    pkg_bump_ns_ew_0_0    1.f
							* r_short_bump_7_1     pkg_bump_ns_ew_7_1    pkg_bump_ns_ew_0_0    1.f
							* r_short_bump_7_2     pkg_bump_ns_ew_7_2    pkg_bump_ns_ew_0_0    1.f
							* r_short_bump_7_3     pkg_bump_ns_ew_7_3    pkg_bump_ns_ew_0_0    1.f
							* r_short_bump_7_4     pkg_bump_ns_ew_7_4    pkg_bump_ns_ew_0_0    1.f
							* r_short_bump_7_5     pkg_bump_ns_ew_7_5    pkg_bump_ns_ew_0_0    1.f
							* r_short_bump_7_6     pkg_bump_ns_ew_7_6    pkg_bump_ns_ew_0_0    1.f
							* r_short_bump_7_7     pkg_bump_ns_ew_7_7    pkg_bump_ns_ew_0_0    1.f
							* r_short_bump_8_0     pkg_bump_ns_ew_8_0    pkg_bump_ns_ew_0_0    1.f
							* r_short_bump_8_1     pkg_bump_ns_ew_8_1    pkg_bump_ns_ew_0_0    1.f
							* r_short_bump_8_2     pkg_bump_ns_ew_8_2    pkg_bump_ns_ew_0_0    1.f
							* r_short_bump_8_3     pkg_bump_ns_ew_8_3    pkg_bump_ns_ew_0_0    1.f
							* r_short_bump_8_4     pkg_bump_ns_ew_8_4    pkg_bump_ns_ew_0_0    1.f
							* r_short_bump_8_5     pkg_bump_ns_ew_8_5    pkg_bump_ns_ew_0_0    1.f
							* r_short_bump_8_6     pkg_bump_ns_ew_8_6    pkg_bump_ns_ew_0_0    1.f
							* r_short_bump_8_7     pkg_bump_ns_ew_8_7    pkg_bump_ns_ew_0_0    1.f
							* r_short_bump_9_0     pkg_bump_ns_ew_9_0    pkg_bump_ns_ew_0_0    1.f
							* r_short_bump_9_1     pkg_bump_ns_ew_9_1    pkg_bump_ns_ew_0_0    1.f
							* r_short_bump_9_2     pkg_bump_ns_ew_9_2    pkg_bump_ns_ew_0_0    1.f
							* r_short_bump_9_3     pkg_bump_ns_ew_9_3    pkg_bump_ns_ew_0_0    1.f
							* r_short_bump_9_4     pkg_bump_ns_ew_9_4    pkg_bump_ns_ew_0_0    1.f
							* r_short_bump_9_5     pkg_bump_ns_ew_9_5    pkg_bump_ns_ew_0_0    1.f
							* r_short_bump_9_6     pkg_bump_ns_ew_9_6    pkg_bump_ns_ew_0_0    1.f
							* r_short_bump_9_7     pkg_bump_ns_ew_9_7    pkg_bump_ns_ew_0_0    1.f
							* r_short_bump_10_0     pkg_bump_ns_ew_10_0  pkg_bump_ns_ew_0_0    1.f
							* r_short_bump_10_1     pkg_bump_ns_ew_10_1  pkg_bump_ns_ew_0_0    1.f
							* r_short_bump_10_2     pkg_bump_ns_ew_10_2  pkg_bump_ns_ew_0_0    1.f
							* r_short_bump_10_3     pkg_bump_ns_ew_10_3  pkg_bump_ns_ew_0_0    1.f
							* r_short_bump_10_4     pkg_bump_ns_ew_10_4  pkg_bump_ns_ew_0_0    1.f
							* r_short_bump_10_5     pkg_bump_ns_ew_10_5  pkg_bump_ns_ew_0_0    1.f
							* r_short_bump_10_6     pkg_bump_ns_ew_10_6  pkg_bump_ns_ew_0_0    1.f
							* r_short_bump_10_7     pkg_bump_ns_ew_10_7  pkg_bump_ns_ew_0_0    1.f
							* r_short_bump_11_0     pkg_bump_ns_ew_11_0  pkg_bump_ns_ew_0_0    1.f
							* r_short_bump_11_1     pkg_bump_ns_ew_11_1  pkg_bump_ns_ew_0_0    1.f
							* r_short_bump_11_2     pkg_bump_ns_ew_11_2  pkg_bump_ns_ew_0_0    1.f
							* r_short_bump_11_3     pkg_bump_ns_ew_11_3  pkg_bump_ns_ew_0_0    1.f
							* r_short_bump_11_4     pkg_bump_ns_ew_11_4  pkg_bump_ns_ew_0_0    1.f
							* r_short_bump_11_5     pkg_bump_ns_ew_11_5  pkg_bump_ns_ew_0_0    1.f
							* r_short_bump_11_6     pkg_bump_ns_ew_11_6  pkg_bump_ns_ew_0_0    1.f
							* r_short_bump_11_7     pkg_bump_ns_ew_11_7  pkg_bump_ns_ew_0_0    1.f
							* r_short_bump_12_0     pkg_bump_ns_ew_12_0  pkg_bump_ns_ew_0_0    1.f
							* r_short_bump_12_1     pkg_bump_ns_ew_12_1  pkg_bump_ns_ew_0_0    1.f
							* r_short_bump_12_2     pkg_bump_ns_ew_12_2  pkg_bump_ns_ew_0_0    1.f
							* r_short_bump_12_3     pkg_bump_ns_ew_12_3  pkg_bump_ns_ew_0_0    1.f
							* r_short_bump_12_4     pkg_bump_ns_ew_12_4  pkg_bump_ns_ew_0_0    1.f
							* r_short_bump_12_5     pkg_bump_ns_ew_12_5  pkg_bump_ns_ew_0_0    1.f
							* r_short_bump_12_6     pkg_bump_ns_ew_12_6  pkg_bump_ns_ew_0_0    1.f
							* r_short_bump_12_7     pkg_bump_ns_ew_12_7  pkg_bump_ns_ew_0_0    1.f
							* r_short_bump_13_0     pkg_bump_ns_ew_13_0  pkg_bump_ns_ew_0_0    1.f
							* r_short_bump_13_1     pkg_bump_ns_ew_13_1  pkg_bump_ns_ew_0_0    1.f
							* r_short_bump_13_2     pkg_bump_ns_ew_13_2  pkg_bump_ns_ew_0_0    1.f
							* r_short_bump_13_3     pkg_bump_ns_ew_13_3  pkg_bump_ns_ew_0_0    1.f
							* r_short_bump_13_4     pkg_bump_ns_ew_13_4  pkg_bump_ns_ew_0_0    1.f
							* r_short_bump_13_5     pkg_bump_ns_ew_13_5  pkg_bump_ns_ew_0_0    1.f
							* r_short_bump_13_6     pkg_bump_ns_ew_13_6  pkg_bump_ns_ew_0_0    1.f
							* r_short_bump_13_7     pkg_bump_ns_ew_13_7  pkg_bump_ns_ew_0_0    1.f
							* r_short_bump_14_0     pkg_bump_ns_ew_14_0  pkg_bump_ns_ew_0_0    1.f
							* r_short_bump_14_1     pkg_bump_ns_ew_14_1  pkg_bump_ns_ew_0_0    1.f
							* r_short_bump_14_2     pkg_bump_ns_ew_14_2  pkg_bump_ns_ew_0_0    1.f
							* r_short_bump_14_3     pkg_bump_ns_ew_14_3  pkg_bump_ns_ew_0_0    1.f
							* r_short_bump_14_4     pkg_bump_ns_ew_14_4  pkg_bump_ns_ew_0_0    1.f
							* r_short_bump_14_5     pkg_bump_ns_ew_14_5  pkg_bump_ns_ew_0_0    1.f
							* r_short_bump_14_6     pkg_bump_ns_ew_14_6  pkg_bump_ns_ew_0_0    1.f
							* r_short_bump_14_7     pkg_bump_ns_ew_14_7  pkg_bump_ns_ew_0_0    1.f
							* r_short_bump_15_0     pkg_bump_ns_ew_15_0  pkg_bump_ns_ew_0_0    1.f
							* r_short_bump_15_1     pkg_bump_ns_ew_15_1  pkg_bump_ns_ew_0_0    1.f
							* r_short_bump_15_2     pkg_bump_ns_ew_15_2  pkg_bump_ns_ew_0_0    1.f
							* r_short_bump_15_3     pkg_bump_ns_ew_15_3  pkg_bump_ns_ew_0_0    1.f
							* r_short_bump_15_4     pkg_bump_ns_ew_15_4  pkg_bump_ns_ew_0_0    1.f
							* r_short_bump_15_5     pkg_bump_ns_ew_15_5  pkg_bump_ns_ew_0_0    1.f
							* r_short_bump_15_6     pkg_bump_ns_ew_15_6  pkg_bump_ns_ew_0_0    1.f
							* r_short_bump_15_7     pkg_bump_ns_ew_15_7  pkg_bump_ns_ew_0_0    1.f
							* r_short_bump_16_0     pkg_bump_ns_ew_16_0  pkg_bump_ns_ew_0_0    1.f
							* r_short_bump_16_1     pkg_bump_ns_ew_16_1  pkg_bump_ns_ew_0_0    1.f
							* r_short_bump_16_2     pkg_bump_ns_ew_16_2  pkg_bump_ns_ew_0_0    1.f
							* r_short_bump_16_3     pkg_bump_ns_ew_16_3  pkg_bump_ns_ew_0_0    1.f
							* r_short_bump_16_4     pkg_bump_ns_ew_16_4  pkg_bump_ns_ew_0_0    1.f
							* r_short_bump_16_5     pkg_bump_ns_ew_16_5  pkg_bump_ns_ew_0_0    1.f
							* r_short_bump_16_6     pkg_bump_ns_ew_16_6  pkg_bump_ns_ew_0_0    1.f
							* r_short_bump_16_7     pkg_bump_ns_ew_16_7  pkg_bump_ns_ew_0_0    1.f
							* r_short_bump_17_0     pkg_bump_ns_ew_17_0  pkg_bump_ns_ew_0_0    1.f
							* r_short_bump_17_1     pkg_bump_ns_ew_17_1  pkg_bump_ns_ew_0_0    1.f
							* r_short_bump_17_2     pkg_bump_ns_ew_17_2  pkg_bump_ns_ew_0_0    1.f
							* r_short_bump_17_3     pkg_bump_ns_ew_17_3  pkg_bump_ns_ew_0_0    1.f
							* r_short_bump_17_4     pkg_bump_ns_ew_17_4  pkg_bump_ns_ew_0_0    1.f
							* r_short_bump_17_5     pkg_bump_ns_ew_17_5  pkg_bump_ns_ew_0_0    1.f
							* r_short_bump_17_6     pkg_bump_ns_ew_17_6  pkg_bump_ns_ew_0_0    1.f
							* r_short_bump_17_7     pkg_bump_ns_ew_17_7  pkg_bump_ns_ew_0_0    1.f
							* r_short_bump_18_0     pkg_bump_ns_ew_18_0  pkg_bump_ns_ew_0_0    1.f
							* r_short_bump_18_1     pkg_bump_ns_ew_18_1  pkg_bump_ns_ew_0_0    1.f
							* r_short_bump_18_2     pkg_bump_ns_ew_18_2  pkg_bump_ns_ew_0_0    1.f
							* r_short_bump_18_3     pkg_bump_ns_ew_18_3  pkg_bump_ns_ew_0_0    1.f
							* r_short_bump_18_4     pkg_bump_ns_ew_18_4  pkg_bump_ns_ew_0_0    1.f
							* r_short_bump_18_5     pkg_bump_ns_ew_18_5  pkg_bump_ns_ew_0_0    1.f
							* r_short_bump_18_6     pkg_bump_ns_ew_18_6  pkg_bump_ns_ew_0_0    1.f
							* r_short_bump_18_7     pkg_bump_ns_ew_18_7  pkg_bump_ns_ew_0_0    1.f
							* r_short_bump_19_0     pkg_bump_ns_ew_19_0  pkg_bump_ns_ew_0_0    1.f
							* r_short_bump_19_1     pkg_bump_ns_ew_19_1  pkg_bump_ns_ew_0_0    1.f
							* r_short_bump_19_2     pkg_bump_ns_ew_19_2  pkg_bump_ns_ew_0_0    1.f
							* r_short_bump_19_3     pkg_bump_ns_ew_19_3  pkg_bump_ns_ew_0_0    1.f
							* r_short_bump_19_4     pkg_bump_ns_ew_19_4  pkg_bump_ns_ew_0_0    1.f
							* r_short_bump_19_5     pkg_bump_ns_ew_19_5  pkg_bump_ns_ew_0_0    1.f
							* r_short_bump_19_6     pkg_bump_ns_ew_19_6  pkg_bump_ns_ew_0_0    1.f
							* r_short_bump_19_7     pkg_bump_ns_ew_19_7  pkg_bump_ns_ew_0_0    1.f
							* r_short_bump_20_0     pkg_bump_ns_ew_20_0  pkg_bump_ns_ew_0_0    1.f
							* r_short_bump_20_1     pkg_bump_ns_ew_20_1  pkg_bump_ns_ew_0_0    1.f
							* r_short_bump_20_2     pkg_bump_ns_ew_20_2  pkg_bump_ns_ew_0_0    1.f
							* r_short_bump_20_3     pkg_bump_ns_ew_20_3  pkg_bump_ns_ew_0_0    1.f
							* r_short_bump_20_4     pkg_bump_ns_ew_20_4  pkg_bump_ns_ew_0_0    1.f
							* r_short_bump_20_5     pkg_bump_ns_ew_20_5  pkg_bump_ns_ew_0_0    1.f
							* r_short_bump_20_6     pkg_bump_ns_ew_20_6  pkg_bump_ns_ew_0_0    1.f
							* r_short_bump_20_7     pkg_bump_ns_ew_20_7  pkg_bump_ns_ew_0_0    1.f
							* r_short_bump_21_0     pkg_bump_ns_ew_21_0  pkg_bump_ns_ew_0_0    1.f
							* r_short_bump_21_1     pkg_bump_ns_ew_21_1  pkg_bump_ns_ew_0_0    1.f
							* r_short_bump_21_2     pkg_bump_ns_ew_21_2  pkg_bump_ns_ew_0_0    1.f
							* r_short_bump_21_3     pkg_bump_ns_ew_21_3  pkg_bump_ns_ew_0_0    1.f
							* r_short_bump_21_4     pkg_bump_ns_ew_21_4  pkg_bump_ns_ew_0_0    1.f
							* r_short_bump_21_5     pkg_bump_ns_ew_21_5  pkg_bump_ns_ew_0_0    1.f
							* r_short_bump_21_6     pkg_bump_ns_ew_21_6  pkg_bump_ns_ew_0_0    1.f
							* r_short_bump_21_7     pkg_bump_ns_ew_21_7  pkg_bump_ns_ew_0_0    1.f
							* r_short_bump_22_0     pkg_bump_ns_ew_22_0  pkg_bump_ns_ew_0_0    1.f
							* r_short_bump_22_1     pkg_bump_ns_ew_22_1  pkg_bump_ns_ew_0_0    1.f
							* r_short_bump_22_2     pkg_bump_ns_ew_22_2  pkg_bump_ns_ew_0_0    1.f
							* r_short_bump_22_3     pkg_bump_ns_ew_22_3  pkg_bump_ns_ew_0_0    1.f
							* r_short_bump_22_4     pkg_bump_ns_ew_22_4  pkg_bump_ns_ew_0_0    1.f
							* r_short_bump_22_5     pkg_bump_ns_ew_22_5  pkg_bump_ns_ew_0_0    1.f
							* r_short_bump_22_6     pkg_bump_ns_ew_22_6  pkg_bump_ns_ew_0_0    1.f
							* r_short_bump_22_7     pkg_bump_ns_ew_22_7  pkg_bump_ns_ew_0_0    1.f
							* r_short_bump_23_0     pkg_bump_ns_ew_23_0  pkg_bump_ns_ew_0_0    1.f
							* r_short_bump_23_1     pkg_bump_ns_ew_23_1  pkg_bump_ns_ew_0_0    1.f
							* r_short_bump_23_2     pkg_bump_ns_ew_23_2  pkg_bump_ns_ew_0_0    1.f
							* r_short_bump_23_3     pkg_bump_ns_ew_23_3  pkg_bump_ns_ew_0_0    1.f
							* r_short_bump_23_4     pkg_bump_ns_ew_23_4  pkg_bump_ns_ew_0_0    1.f
							* r_short_bump_23_5     pkg_bump_ns_ew_23_5  pkg_bump_ns_ew_0_0    1.f
							* r_short_bump_23_6     pkg_bump_ns_ew_23_6  pkg_bump_ns_ew_0_0    1.f
							* r_short_bump_23_7     pkg_bump_ns_ew_23_7  pkg_bump_ns_ew_0_0    1.f

							*** debug to short all BGA together
							* r_short_BGA_2_7        bga_2_7		bga_3_7     1.f
							* r_short_BGA_1_7        bga_1_7        bga_3_7     1.f
							* r_short_BGA_0_7        bga_0_7        bga_3_7     1.f
							* r_short_BGA_3_6        bga_3_6        bga_3_7     1.f
							* r_short_BGA_2_6        bga_2_6        bga_3_7     1.f
							* r_short_BGA_1_6        bga_1_6        bga_3_7     1.f
							* r_short_BGA_0_6        bga_0_6        bga_3_7     1.f
							* r_short_BGA_3_5        bga_3_5        bga_3_7     1.f
							* r_short_BGA_2_5        bga_2_5        bga_3_7     1.f
							* r_short_BGA_1_5        bga_1_5        bga_3_7     1.f
							* r_short_BGA_0_5        bga_0_5        bga_3_7     1.f
							* r_short_BGA_3_4        bga_3_4        bga_3_7     1.f
							* r_short_BGA_2_4        bga_2_4        bga_3_7     1.f
							* r_short_BGA_1_4        bga_1_4        bga_3_7     1.f
							* r_short_BGA_0_4        bga_0_4        bga_3_7     1.f
							* r_short_BGA_3_3        bga_3_3        bga_3_7     1.f
							* r_short_BGA_2_3        bga_2_3        bga_3_7     1.f
							* r_short_BGA_1_3        bga_1_3        bga_3_7     1.f
							* r_short_BGA_0_3        bga_0_3        bga_3_7     1.f
							* r_short_BGA_3_2        bga_3_2        bga_3_7     1.f
							* r_short_BGA_2_2        bga_2_2        bga_3_7     1.f
							* r_short_BGA_1_2        bga_1_2        bga_3_7     1.f
							* r_short_BGA_0_2        bga_0_2        bga_3_7     1.f
							* r_short_BGA_3_1        bga_3_1        bga_3_7     1.f
							* r_short_BGA_2_1        bga_2_1        bga_3_7     1.f
							* r_short_BGA_1_1        bga_1_1        bga_3_7     1.f
							* r_short_BGA_0_1        bga_0_1        bga_3_7     1.f
							* r_short_BGA_3_0        bga_3_0        bga_3_7     1.f
							* r_short_BGA_2_0        bga_2_0        bga_3_7     1.f
							* r_short_BGA_1_0        bga_1_0        bga_3_7     1.f
							* r_short_BGA_0_0        bga_0_0        bga_3_7     1.f
							* r_short_BGA_OUT_0_1    bga_OUT_0_1    bga_3_7     1.f
							* r_short_BGA_OUT_0_2    bga_OUT_0_2    bga_3_7     1.f
							* r_short_BGA_OUT_0_3    bga_OUT_0_3    bga_3_7     1.f
							* r_short_BGA_OUT_0_4    bga_OUT_0_4    bga_3_7     1.f
							* r_short_BGA_OUT_1_1    bga_OUT_1_1    bga_3_7     1.f
							* r_short_BGA_OUT_1_2    bga_OUT_1_2    bga_3_7     1.f
							* r_short_BGA_OUT_1_3    bga_OUT_1_3    bga_3_7     1.f
							* r_short_BGA_OUT_1_4    bga_OUT_1_4    bga_3_7     1.f

							*** debug end

*************************************** PCB ***********************************
					*** debug to skip PCB
					* R_short_pcb bga_pkg 	pmic_pwr	1.n

* Xblk_PCB		*** 240912 8x phase solution
* + pmic_pwr
* + pmic_pwr
* + pmic_pwr
* + pmic_pwr
* + pmic_pwr
* + pmic_pwr
* + pmic_pwr
* + pmic_pwr
* + bga_pcb_0_w_skt
* + bga_pcb_1_w_skt
* + bga_pcb_2_w_skt
* + bga_pcb_3_w_skt
* + bga_pcb_4_w_skt
* + bga_pcb_5_w_skt
* + ref_gnd
* * + ACM3_250223_8phases_BGAx6_discrt_IdEM
* + NNE_SiVal_revC_250808_6xBGA_8phases_s14p_IdEM

Xblk_PCB 	*** POR
+ pmic_pwr
+ pmic_pwr
+ pmic_pwr
+ pmic_pwr
+ pmic_pwr
+ pmic_pwr
+ pmic_pwr
+ pmic_pwr
+ bga_3_7
+ bga_2_7
+ bga_1_7
+ bga_0_7
+ bga_3_6
+ bga_2_6
+ bga_1_6
+ bga_0_6
+ bga_3_5
+ bga_2_5
+ bga_1_5
+ bga_0_5
+ bga_3_4
+ bga_2_4
+ bga_1_4
+ bga_0_4
+ bga_3_3
+ bga_2_3
+ bga_1_3
+ bga_0_3
+ bga_3_2
+ bga_2_2
+ bga_1_2
+ bga_0_2
+ bga_3_1
+ bga_2_1
+ bga_1_1
+ bga_0_1
+ bga_3_0
+ bga_2_0
+ bga_1_0
+ bga_0_0
+ bga_OUT_0_1
+ bga_OUT_0_2
+ bga_OUT_0_3
+ bga_OUT_0_4
+ bga_OUT_1_1
+ bga_OUT_1_2
+ bga_OUT_1_3
+ bga_OUT_1_4
+ ref_gnd
* + NNE_SiVal_revC_251028_BGA8x8_modif_IdEM_s48p
+ NNE_ACM3_C0_260108_redu_IdEM 	*** POR

				* *** S-para (only for AC sim)
				* .model pcb_spara_model S
				* + TSTONEFILE = '/data/home/jiangongwei/work/PDN_core/hspice_inc/ACM3_A0_241126_cut_NNE_6xPhase_BGAx6_testcase3_kyo1uF.s12p'
				* + FMAX= 1G

				* S_blk_PCB
				* + pmic_pwr
				* + pmic_pwr
				* + pmic_pwr
				* + pmic_pwr
				* + pmic_pwr
				* + pmic_pwr
				* + bga_pcb_0
				* + bga_pcb_1
				* + bga_pcb_2
				* + bga_pcb_3
				* + bga_pcb_4
				* + bga_pcb_5
				* + ref_gnd
				* + mname = pcb_spara_model
				* ***

				* *** S-para (only for AC sim)
				* .model pcb_spara_model S
				* * + TSTONEFILE = '/data/home/jiangongwei/work/PDN_core/hspice_inc/NNE_ACM3_250222_frPoppySIW_jgwei_6xBGA.s14p'
				* * + TSTONEFILE = '/data/home/jiangongwei/work/PDN_core/hspice_inc/SiVal_C_02192025_plug_ts.s14p'						*** Poppy generated 3x2 BGA
				* + TSTONEFILE = '/data/home/jiangongwei/work/port_reduction/NNE_ACM3_250222_fr_PoppySIW/ACM3_250223_8phases_BGAx6_discrt.s14p'		*** discrete sweep, 122 freq pts
				* + FMAX= 1G

				* S_blk_PCB
				* + pmic_pwr
				* + pmic_pwr
				* + pmic_pwr
				* + pmic_pwr
				* + pmic_pwr
				* + pmic_pwr
				* + pmic_pwr
				* + pmic_pwr
				* + bga_pcb_0
				* + bga_pcb_1
				* + bga_pcb_2
				* + bga_pcb_3
				* + bga_pcb_4
				* + bga_pcb_5
				* + ref_gnd
				* + mname = pcb_spara_model
				* ***

*** IVR experiment
* Xblk_pkg		*** 4x IVR at pkg back side, 3x Ecap, *** NEED to Disconnect board ***
* + pkg_bump_ns_ew_0_0_pkgPad
* + pkg_bump_ns_ew_0_1_pkgPad
* + pkg_bump_ns_ew_0_2_pkgPad
* + pkg_bump_ns_ew_0_3_pkgPad
* + pkg_bump_ns_ew_0_4_pkgPad
* + pkg_bump_ns_ew_0_5_pkgPad
* + pkg_bump_ns_ew_0_6_pkgPad
* + pkg_bump_ns_ew_0_7_pkgPad
* + pkg_bump_ns_ew_1_0_pkgPad
* + pkg_bump_ns_ew_1_1_pkgPad
* + pkg_bump_ns_ew_1_2_pkgPad
* + pkg_bump_ns_ew_1_3_pkgPad
* + pkg_bump_ns_ew_1_4_pkgPad
* + pkg_bump_ns_ew_1_5_pkgPad
* + pkg_bump_ns_ew_1_6_pkgPad
* + pkg_bump_ns_ew_1_7_pkgPad
* + pkg_bump_ns_ew_2_0_pkgPad
* + pkg_bump_ns_ew_2_1_pkgPad
* + pkg_bump_ns_ew_2_2_pkgPad
* + pkg_bump_ns_ew_2_3_pkgPad
* + pkg_bump_ns_ew_2_4_pkgPad
* + pkg_bump_ns_ew_2_5_pkgPad
* + pkg_bump_ns_ew_2_6_pkgPad
* + pkg_bump_ns_ew_2_7_pkgPad
* + pkg_bump_ns_ew_3_0_pkgPad
* + pkg_bump_ns_ew_3_1_pkgPad
* + pkg_bump_ns_ew_3_2_pkgPad
* + pkg_bump_ns_ew_3_3_pkgPad
* + pkg_bump_ns_ew_3_4_pkgPad
* + pkg_bump_ns_ew_3_5_pkgPad
* + pkg_bump_ns_ew_3_6_pkgPad
* + pkg_bump_ns_ew_3_7_pkgPad
* + pkg_bump_ns_ew_4_0_pkgPad
* + pkg_bump_ns_ew_4_1_pkgPad
* + pkg_bump_ns_ew_4_2_pkgPad
* + pkg_bump_ns_ew_4_3_pkgPad
* + pkg_bump_ns_ew_4_4_pkgPad
* + pkg_bump_ns_ew_4_5_pkgPad
* + pkg_bump_ns_ew_4_6_pkgPad
* + pkg_bump_ns_ew_4_7_pkgPad
* + pkg_bump_ns_ew_5_0_pkgPad
* + pkg_bump_ns_ew_5_1_pkgPad
* + pkg_bump_ns_ew_5_2_pkgPad
* + pkg_bump_ns_ew_5_3_pkgPad
* + pkg_bump_ns_ew_5_4_pkgPad
* + pkg_bump_ns_ew_5_5_pkgPad
* + pkg_bump_ns_ew_5_6_pkgPad
* + pkg_bump_ns_ew_5_7_pkgPad
* + pkg_bump_ns_ew_6_0_pkgPad
* + pkg_bump_ns_ew_6_1_pkgPad
* + pkg_bump_ns_ew_6_2_pkgPad
* + pkg_bump_ns_ew_6_3_pkgPad
* + pkg_bump_ns_ew_6_4_pkgPad
* + pkg_bump_ns_ew_6_5_pkgPad
* + pkg_bump_ns_ew_6_6_pkgPad
* + pkg_bump_ns_ew_6_7_pkgPad
* + pkg_bump_ns_ew_7_0_pkgPad
* + pkg_bump_ns_ew_7_1_pkgPad
* + pkg_bump_ns_ew_7_2_pkgPad
* + pkg_bump_ns_ew_7_3_pkgPad
* + pkg_bump_ns_ew_7_4_pkgPad
* + pkg_bump_ns_ew_7_5_pkgPad
* + pkg_bump_ns_ew_7_6_pkgPad
* + pkg_bump_ns_ew_7_7_pkgPad
* + pkg_bump_ns_ew_8_0_pkgPad
* + pkg_bump_ns_ew_8_1_pkgPad
* + pkg_bump_ns_ew_8_2_pkgPad
* + pkg_bump_ns_ew_8_3_pkgPad
* + pkg_bump_ns_ew_8_4_pkgPad
* + pkg_bump_ns_ew_8_5_pkgPad
* + pkg_bump_ns_ew_8_6_pkgPad
* + pkg_bump_ns_ew_8_7_pkgPad
* + pkg_bump_ns_ew_9_0_pkgPad
* + pkg_bump_ns_ew_9_1_pkgPad
* + pkg_bump_ns_ew_9_2_pkgPad
* + pkg_bump_ns_ew_9_3_pkgPad
* + pkg_bump_ns_ew_9_4_pkgPad
* + pkg_bump_ns_ew_9_5_pkgPad
* + pkg_bump_ns_ew_9_6_pkgPad
* + pkg_bump_ns_ew_9_7_pkgPad
* + pkg_bump_ns_ew_10_0_pkgPad
* + pkg_bump_ns_ew_10_1_pkgPad
* + pkg_bump_ns_ew_10_2_pkgPad
* + pkg_bump_ns_ew_10_3_pkgPad
* + pkg_bump_ns_ew_10_4_pkgPad
* + pkg_bump_ns_ew_10_5_pkgPad
* + pkg_bump_ns_ew_10_6_pkgPad
* + pkg_bump_ns_ew_10_7_pkgPad
* + pkg_bump_ns_ew_11_0_pkgPad
* + pkg_bump_ns_ew_11_1_pkgPad
* + pkg_bump_ns_ew_11_2_pkgPad
* + pkg_bump_ns_ew_11_3_pkgPad
* + pkg_bump_ns_ew_11_4_pkgPad
* + pkg_bump_ns_ew_11_5_pkgPad
* + pkg_bump_ns_ew_11_6_pkgPad
* + pkg_bump_ns_ew_11_7_pkgPad
* + pkg_bump_ns_ew_12_0_pkgPad
* + pkg_bump_ns_ew_12_1_pkgPad
* + pkg_bump_ns_ew_12_2_pkgPad
* + pkg_bump_ns_ew_12_3_pkgPad
* + pkg_bump_ns_ew_12_4_pkgPad
* + pkg_bump_ns_ew_12_5_pkgPad
* + pkg_bump_ns_ew_12_6_pkgPad
* + pkg_bump_ns_ew_12_7_pkgPad
* + pkg_bump_ns_ew_13_0_pkgPad
* + pkg_bump_ns_ew_13_1_pkgPad
* + pkg_bump_ns_ew_13_2_pkgPad
* + pkg_bump_ns_ew_13_3_pkgPad
* + pkg_bump_ns_ew_13_4_pkgPad
* + pkg_bump_ns_ew_13_5_pkgPad
* + pkg_bump_ns_ew_13_6_pkgPad
* + pkg_bump_ns_ew_13_7_pkgPad
* + pkg_bump_ns_ew_14_0_pkgPad
* + pkg_bump_ns_ew_14_1_pkgPad
* + pkg_bump_ns_ew_14_2_pkgPad
* + pkg_bump_ns_ew_14_3_pkgPad
* + pkg_bump_ns_ew_14_4_pkgPad
* + pkg_bump_ns_ew_14_5_pkgPad
* + pkg_bump_ns_ew_14_6_pkgPad
* + pkg_bump_ns_ew_14_7_pkgPad
* + pkg_bump_ns_ew_15_0_pkgPad
* + pkg_bump_ns_ew_15_1_pkgPad
* + pkg_bump_ns_ew_15_2_pkgPad
* + pkg_bump_ns_ew_15_3_pkgPad
* + pkg_bump_ns_ew_15_4_pkgPad
* + pkg_bump_ns_ew_15_5_pkgPad
* + pkg_bump_ns_ew_15_6_pkgPad
* + pkg_bump_ns_ew_15_7_pkgPad
* + pkg_bump_ns_ew_16_0_pkgPad
* + pkg_bump_ns_ew_16_1_pkgPad
* + pkg_bump_ns_ew_16_2_pkgPad
* + pkg_bump_ns_ew_16_3_pkgPad
* + pkg_bump_ns_ew_16_4_pkgPad
* + pkg_bump_ns_ew_16_5_pkgPad
* + pkg_bump_ns_ew_16_6_pkgPad
* + pkg_bump_ns_ew_16_7_pkgPad
* + pkg_bump_ns_ew_17_0_pkgPad
* + pkg_bump_ns_ew_17_1_pkgPad
* + pkg_bump_ns_ew_17_2_pkgPad
* + pkg_bump_ns_ew_17_3_pkgPad
* + pkg_bump_ns_ew_17_4_pkgPad
* + pkg_bump_ns_ew_17_5_pkgPad
* + pkg_bump_ns_ew_17_6_pkgPad
* + pkg_bump_ns_ew_17_7_pkgPad
* + pkg_bump_ns_ew_18_0_pkgPad
* + pkg_bump_ns_ew_18_1_pkgPad
* + pkg_bump_ns_ew_18_2_pkgPad
* + pkg_bump_ns_ew_18_3_pkgPad
* + pkg_bump_ns_ew_18_4_pkgPad
* + pkg_bump_ns_ew_18_5_pkgPad
* + pkg_bump_ns_ew_18_6_pkgPad
* + pkg_bump_ns_ew_18_7_pkgPad
* + pkg_bump_ns_ew_19_0_pkgPad
* + pkg_bump_ns_ew_19_1_pkgPad
* + pkg_bump_ns_ew_19_2_pkgPad
* + pkg_bump_ns_ew_19_3_pkgPad
* + pkg_bump_ns_ew_19_4_pkgPad
* + pkg_bump_ns_ew_19_5_pkgPad
* + pkg_bump_ns_ew_19_6_pkgPad
* + pkg_bump_ns_ew_19_7_pkgPad
* + pkg_bump_ns_ew_20_0_pkgPad
* + pkg_bump_ns_ew_20_1_pkgPad
* + pkg_bump_ns_ew_20_2_pkgPad
* + pkg_bump_ns_ew_20_3_pkgPad
* + pkg_bump_ns_ew_20_4_pkgPad
* + pkg_bump_ns_ew_20_5_pkgPad
* + pkg_bump_ns_ew_20_6_pkgPad
* + pkg_bump_ns_ew_20_7_pkgPad
* + pkg_bump_ns_ew_21_0_pkgPad
* + pkg_bump_ns_ew_21_1_pkgPad
* + pkg_bump_ns_ew_21_2_pkgPad
* + pkg_bump_ns_ew_21_3_pkgPad
* + pkg_bump_ns_ew_21_4_pkgPad
* + pkg_bump_ns_ew_21_5_pkgPad
* + pkg_bump_ns_ew_21_6_pkgPad
* + pkg_bump_ns_ew_21_7_pkgPad
* + pkg_bump_ns_ew_22_0_pkgPad
* + pkg_bump_ns_ew_22_1_pkgPad
* + pkg_bump_ns_ew_22_2_pkgPad
* + pkg_bump_ns_ew_22_3_pkgPad
* + pkg_bump_ns_ew_22_4_pkgPad
* + pkg_bump_ns_ew_22_5_pkgPad
* + pkg_bump_ns_ew_22_6_pkgPad
* + pkg_bump_ns_ew_22_7_pkgPad
* + pkg_bump_ns_ew_23_0_pkgPad
* + pkg_bump_ns_ew_23_1_pkgPad
* + pkg_bump_ns_ew_23_2_pkgPad
* + pkg_bump_ns_ew_23_3_pkgPad
* + pkg_bump_ns_ew_23_4_pkgPad
* + pkg_bump_ns_ew_23_5_pkgPad
* + pkg_bump_ns_ew_23_6_pkgPad
* + pkg_bump_ns_ew_23_7_pkgPad
* + pmic_pwr
* + pmic_pwr
* + pmic_pwr
* + pmic_pwr
* + pkge_Ecap1_2x2mm_1
* + pkge_Ecap1_2x2mm_2
* + pkge_Ecap2_2x2mm_1
* + pkge_Ecap2_2x2mm_2
* + pkge_Ecap3_2x2mm_1
* + pkge_Ecap3_2x2mm_2
* + dummy_IVR0_0
* + dummy_IVR0_1
* + dummy_IVR1_0
* + dummy_IVR1_1
* + dummy_IVR2_0
* + dummy_IVR2_1
* + dummy_IVR3_0
* + dummy_IVR3_1
* + ref_gnd
* + sip_op2_ferric_072525_2_cut_NNE_die24x8_redu_IdEM

*************************************** Pkg ***********************************

***** bump level DTC mockup
.if (is_bump_DTC == 1)
	xEcapDTC_0_0     pkg_bump_ns_ew_0_0    pkg_bump_ns_ew_0_0_pkgPad      ref_gnd  siCap_bump_samsung_0p4mmX1mm
	xEcapDTC_0_1     pkg_bump_ns_ew_0_1    pkg_bump_ns_ew_0_1_pkgPad      ref_gnd  siCap_bump_samsung_0p4mmX1mm
	xEcapDTC_0_2     pkg_bump_ns_ew_0_2    pkg_bump_ns_ew_0_2_pkgPad      ref_gnd  siCap_bump_samsung_0p4mmX1mm
	xEcapDTC_0_3     pkg_bump_ns_ew_0_3    pkg_bump_ns_ew_0_3_pkgPad      ref_gnd  siCap_bump_samsung_0p4mmX1mm
	xEcapDTC_0_4     pkg_bump_ns_ew_0_4    pkg_bump_ns_ew_0_4_pkgPad      ref_gnd  siCap_bump_samsung_0p4mmX1mm
	xEcapDTC_0_5     pkg_bump_ns_ew_0_5    pkg_bump_ns_ew_0_5_pkgPad      ref_gnd  siCap_bump_samsung_0p4mmX1mm
	xEcapDTC_0_6     pkg_bump_ns_ew_0_6    pkg_bump_ns_ew_0_6_pkgPad      ref_gnd  siCap_bump_samsung_0p4mmX1mm
	xEcapDTC_0_7     pkg_bump_ns_ew_0_7    pkg_bump_ns_ew_0_7_pkgPad      ref_gnd  siCap_bump_samsung_0p4mmX1mm
	xEcapDTC_1_0     pkg_bump_ns_ew_1_0    pkg_bump_ns_ew_1_0_pkgPad      ref_gnd  siCap_bump_samsung_0p4mmX1mm
	xEcapDTC_1_1     pkg_bump_ns_ew_1_1    pkg_bump_ns_ew_1_1_pkgPad      ref_gnd  siCap_bump_samsung_0p4mmX1mm
	xEcapDTC_1_2     pkg_bump_ns_ew_1_2    pkg_bump_ns_ew_1_2_pkgPad      ref_gnd  siCap_bump_samsung_0p4mmX1mm
	xEcapDTC_1_3     pkg_bump_ns_ew_1_3    pkg_bump_ns_ew_1_3_pkgPad      ref_gnd  siCap_bump_samsung_0p4mmX1mm
	xEcapDTC_1_4     pkg_bump_ns_ew_1_4    pkg_bump_ns_ew_1_4_pkgPad      ref_gnd  siCap_bump_samsung_0p4mmX1mm
	xEcapDTC_1_5     pkg_bump_ns_ew_1_5    pkg_bump_ns_ew_1_5_pkgPad      ref_gnd  siCap_bump_samsung_0p4mmX1mm
	xEcapDTC_1_6     pkg_bump_ns_ew_1_6    pkg_bump_ns_ew_1_6_pkgPad      ref_gnd  siCap_bump_samsung_0p4mmX1mm
	xEcapDTC_1_7     pkg_bump_ns_ew_1_7    pkg_bump_ns_ew_1_7_pkgPad      ref_gnd  siCap_bump_samsung_0p4mmX1mm
	xEcapDTC_2_0     pkg_bump_ns_ew_2_0    pkg_bump_ns_ew_2_0_pkgPad      ref_gnd  siCap_bump_samsung_0p4mmX1mm
	xEcapDTC_2_1     pkg_bump_ns_ew_2_1    pkg_bump_ns_ew_2_1_pkgPad      ref_gnd  siCap_bump_samsung_0p4mmX1mm
	xEcapDTC_2_2     pkg_bump_ns_ew_2_2    pkg_bump_ns_ew_2_2_pkgPad      ref_gnd  siCap_bump_samsung_0p4mmX1mm
	xEcapDTC_2_3     pkg_bump_ns_ew_2_3    pkg_bump_ns_ew_2_3_pkgPad      ref_gnd  siCap_bump_samsung_0p4mmX1mm
	xEcapDTC_2_4     pkg_bump_ns_ew_2_4    pkg_bump_ns_ew_2_4_pkgPad      ref_gnd  siCap_bump_samsung_0p4mmX1mm
	xEcapDTC_2_5     pkg_bump_ns_ew_2_5    pkg_bump_ns_ew_2_5_pkgPad      ref_gnd  siCap_bump_samsung_0p4mmX1mm
	xEcapDTC_2_6     pkg_bump_ns_ew_2_6    pkg_bump_ns_ew_2_6_pkgPad      ref_gnd  siCap_bump_samsung_0p4mmX1mm
	xEcapDTC_2_7     pkg_bump_ns_ew_2_7    pkg_bump_ns_ew_2_7_pkgPad      ref_gnd  siCap_bump_samsung_0p4mmX1mm
	xEcapDTC_3_0     pkg_bump_ns_ew_3_0    pkg_bump_ns_ew_3_0_pkgPad      ref_gnd  siCap_bump_samsung_0p4mmX1mm
	xEcapDTC_3_1     pkg_bump_ns_ew_3_1    pkg_bump_ns_ew_3_1_pkgPad      ref_gnd  siCap_bump_samsung_0p4mmX1mm
	xEcapDTC_3_2     pkg_bump_ns_ew_3_2    pkg_bump_ns_ew_3_2_pkgPad      ref_gnd  siCap_bump_samsung_0p4mmX1mm
	xEcapDTC_3_3     pkg_bump_ns_ew_3_3    pkg_bump_ns_ew_3_3_pkgPad      ref_gnd  siCap_bump_samsung_0p4mmX1mm
	xEcapDTC_3_4     pkg_bump_ns_ew_3_4    pkg_bump_ns_ew_3_4_pkgPad      ref_gnd  siCap_bump_samsung_0p4mmX1mm
	xEcapDTC_3_5     pkg_bump_ns_ew_3_5    pkg_bump_ns_ew_3_5_pkgPad      ref_gnd  siCap_bump_samsung_0p4mmX1mm
	xEcapDTC_3_6     pkg_bump_ns_ew_3_6    pkg_bump_ns_ew_3_6_pkgPad      ref_gnd  siCap_bump_samsung_0p4mmX1mm
	xEcapDTC_3_7     pkg_bump_ns_ew_3_7    pkg_bump_ns_ew_3_7_pkgPad      ref_gnd  siCap_bump_samsung_0p4mmX1mm
	xEcapDTC_4_0     pkg_bump_ns_ew_4_0    pkg_bump_ns_ew_4_0_pkgPad      ref_gnd  siCap_bump_samsung_0p4mmX1mm
	xEcapDTC_4_1     pkg_bump_ns_ew_4_1    pkg_bump_ns_ew_4_1_pkgPad      ref_gnd  siCap_bump_samsung_0p4mmX1mm
	xEcapDTC_4_2     pkg_bump_ns_ew_4_2    pkg_bump_ns_ew_4_2_pkgPad      ref_gnd  siCap_bump_samsung_0p4mmX1mm
	xEcapDTC_4_3     pkg_bump_ns_ew_4_3    pkg_bump_ns_ew_4_3_pkgPad      ref_gnd  siCap_bump_samsung_0p4mmX1mm
	xEcapDTC_4_4     pkg_bump_ns_ew_4_4    pkg_bump_ns_ew_4_4_pkgPad      ref_gnd  siCap_bump_samsung_0p4mmX1mm
	xEcapDTC_4_5     pkg_bump_ns_ew_4_5    pkg_bump_ns_ew_4_5_pkgPad      ref_gnd  siCap_bump_samsung_0p4mmX1mm
	xEcapDTC_4_6     pkg_bump_ns_ew_4_6    pkg_bump_ns_ew_4_6_pkgPad      ref_gnd  siCap_bump_samsung_0p4mmX1mm
	xEcapDTC_4_7     pkg_bump_ns_ew_4_7    pkg_bump_ns_ew_4_7_pkgPad      ref_gnd  siCap_bump_samsung_0p4mmX1mm
	xEcapDTC_5_0     pkg_bump_ns_ew_5_0    pkg_bump_ns_ew_5_0_pkgPad      ref_gnd  siCap_bump_samsung_0p4mmX1mm
	xEcapDTC_5_1     pkg_bump_ns_ew_5_1    pkg_bump_ns_ew_5_1_pkgPad      ref_gnd  siCap_bump_samsung_0p4mmX1mm
	xEcapDTC_5_2     pkg_bump_ns_ew_5_2    pkg_bump_ns_ew_5_2_pkgPad      ref_gnd  siCap_bump_samsung_0p4mmX1mm
	xEcapDTC_5_3     pkg_bump_ns_ew_5_3    pkg_bump_ns_ew_5_3_pkgPad      ref_gnd  siCap_bump_samsung_0p4mmX1mm
	xEcapDTC_5_4     pkg_bump_ns_ew_5_4    pkg_bump_ns_ew_5_4_pkgPad      ref_gnd  siCap_bump_samsung_0p4mmX1mm
	xEcapDTC_5_5     pkg_bump_ns_ew_5_5    pkg_bump_ns_ew_5_5_pkgPad      ref_gnd  siCap_bump_samsung_0p4mmX1mm
	xEcapDTC_5_6     pkg_bump_ns_ew_5_6    pkg_bump_ns_ew_5_6_pkgPad      ref_gnd  siCap_bump_samsung_0p4mmX1mm
	xEcapDTC_5_7     pkg_bump_ns_ew_5_7    pkg_bump_ns_ew_5_7_pkgPad      ref_gnd  siCap_bump_samsung_0p4mmX1mm
	xEcapDTC_6_0     pkg_bump_ns_ew_6_0    pkg_bump_ns_ew_6_0_pkgPad      ref_gnd  siCap_bump_samsung_0p4mmX1mm
	xEcapDTC_6_1     pkg_bump_ns_ew_6_1    pkg_bump_ns_ew_6_1_pkgPad      ref_gnd  siCap_bump_samsung_0p4mmX1mm
	xEcapDTC_6_2     pkg_bump_ns_ew_6_2    pkg_bump_ns_ew_6_2_pkgPad      ref_gnd  siCap_bump_samsung_0p4mmX1mm
	xEcapDTC_6_3     pkg_bump_ns_ew_6_3    pkg_bump_ns_ew_6_3_pkgPad      ref_gnd  siCap_bump_samsung_0p4mmX1mm
	xEcapDTC_6_4     pkg_bump_ns_ew_6_4    pkg_bump_ns_ew_6_4_pkgPad      ref_gnd  siCap_bump_samsung_0p4mmX1mm
	xEcapDTC_6_5     pkg_bump_ns_ew_6_5    pkg_bump_ns_ew_6_5_pkgPad      ref_gnd  siCap_bump_samsung_0p4mmX1mm
	xEcapDTC_6_6     pkg_bump_ns_ew_6_6    pkg_bump_ns_ew_6_6_pkgPad      ref_gnd  siCap_bump_samsung_0p4mmX1mm
	xEcapDTC_6_7     pkg_bump_ns_ew_6_7    pkg_bump_ns_ew_6_7_pkgPad      ref_gnd  siCap_bump_samsung_0p4mmX1mm
	xEcapDTC_7_0     pkg_bump_ns_ew_7_0    pkg_bump_ns_ew_7_0_pkgPad      ref_gnd  siCap_bump_samsung_0p4mmX1mm
	xEcapDTC_7_1     pkg_bump_ns_ew_7_1    pkg_bump_ns_ew_7_1_pkgPad      ref_gnd  siCap_bump_samsung_0p4mmX1mm
	xEcapDTC_7_2     pkg_bump_ns_ew_7_2    pkg_bump_ns_ew_7_2_pkgPad      ref_gnd  siCap_bump_samsung_0p4mmX1mm
	xEcapDTC_7_3     pkg_bump_ns_ew_7_3    pkg_bump_ns_ew_7_3_pkgPad      ref_gnd  siCap_bump_samsung_0p4mmX1mm
	xEcapDTC_7_4     pkg_bump_ns_ew_7_4    pkg_bump_ns_ew_7_4_pkgPad      ref_gnd  siCap_bump_samsung_0p4mmX1mm
	xEcapDTC_7_5     pkg_bump_ns_ew_7_5    pkg_bump_ns_ew_7_5_pkgPad      ref_gnd  siCap_bump_samsung_0p4mmX1mm
	xEcapDTC_7_6     pkg_bump_ns_ew_7_6    pkg_bump_ns_ew_7_6_pkgPad      ref_gnd  siCap_bump_samsung_0p4mmX1mm
	xEcapDTC_7_7     pkg_bump_ns_ew_7_7    pkg_bump_ns_ew_7_7_pkgPad      ref_gnd  siCap_bump_samsung_0p4mmX1mm
	xEcapDTC_8_0     pkg_bump_ns_ew_8_0    pkg_bump_ns_ew_8_0_pkgPad      ref_gnd  siCap_bump_samsung_0p4mmX1mm
	xEcapDTC_8_1     pkg_bump_ns_ew_8_1    pkg_bump_ns_ew_8_1_pkgPad      ref_gnd  siCap_bump_samsung_0p4mmX1mm
	xEcapDTC_8_2     pkg_bump_ns_ew_8_2    pkg_bump_ns_ew_8_2_pkgPad      ref_gnd  siCap_bump_samsung_0p4mmX1mm
	xEcapDTC_8_3     pkg_bump_ns_ew_8_3    pkg_bump_ns_ew_8_3_pkgPad      ref_gnd  siCap_bump_samsung_0p4mmX1mm
	xEcapDTC_8_4     pkg_bump_ns_ew_8_4    pkg_bump_ns_ew_8_4_pkgPad      ref_gnd  siCap_bump_samsung_0p4mmX1mm
	xEcapDTC_8_5     pkg_bump_ns_ew_8_5    pkg_bump_ns_ew_8_5_pkgPad      ref_gnd  siCap_bump_samsung_0p4mmX1mm
	xEcapDTC_8_6     pkg_bump_ns_ew_8_6    pkg_bump_ns_ew_8_6_pkgPad      ref_gnd  siCap_bump_samsung_0p4mmX1mm
	xEcapDTC_8_7     pkg_bump_ns_ew_8_7    pkg_bump_ns_ew_8_7_pkgPad      ref_gnd  siCap_bump_samsung_0p4mmX1mm
	xEcapDTC_9_0     pkg_bump_ns_ew_9_0    pkg_bump_ns_ew_9_0_pkgPad      ref_gnd  siCap_bump_samsung_0p4mmX1mm
	xEcapDTC_9_1     pkg_bump_ns_ew_9_1    pkg_bump_ns_ew_9_1_pkgPad      ref_gnd  siCap_bump_samsung_0p4mmX1mm
	xEcapDTC_9_2     pkg_bump_ns_ew_9_2    pkg_bump_ns_ew_9_2_pkgPad      ref_gnd  siCap_bump_samsung_0p4mmX1mm
	xEcapDTC_9_3     pkg_bump_ns_ew_9_3    pkg_bump_ns_ew_9_3_pkgPad      ref_gnd  siCap_bump_samsung_0p4mmX1mm
	xEcapDTC_9_4     pkg_bump_ns_ew_9_4    pkg_bump_ns_ew_9_4_pkgPad      ref_gnd  siCap_bump_samsung_0p4mmX1mm
	xEcapDTC_9_5     pkg_bump_ns_ew_9_5    pkg_bump_ns_ew_9_5_pkgPad      ref_gnd  siCap_bump_samsung_0p4mmX1mm
	xEcapDTC_9_6     pkg_bump_ns_ew_9_6    pkg_bump_ns_ew_9_6_pkgPad      ref_gnd  siCap_bump_samsung_0p4mmX1mm
	xEcapDTC_9_7     pkg_bump_ns_ew_9_7    pkg_bump_ns_ew_9_7_pkgPad      ref_gnd  siCap_bump_samsung_0p4mmX1mm
	xEcapDTC_10_0    pkg_bump_ns_ew_10_0    pkg_bump_ns_ew_10_0_pkgPad    ref_gnd  siCap_bump_samsung_0p4mmX1mm
	xEcapDTC_10_1    pkg_bump_ns_ew_10_1    pkg_bump_ns_ew_10_1_pkgPad    ref_gnd  siCap_bump_samsung_0p4mmX1mm
	xEcapDTC_10_2    pkg_bump_ns_ew_10_2    pkg_bump_ns_ew_10_2_pkgPad    ref_gnd  siCap_bump_samsung_0p4mmX1mm
	xEcapDTC_10_3    pkg_bump_ns_ew_10_3    pkg_bump_ns_ew_10_3_pkgPad    ref_gnd  siCap_bump_samsung_0p4mmX1mm
	xEcapDTC_10_4    pkg_bump_ns_ew_10_4    pkg_bump_ns_ew_10_4_pkgPad    ref_gnd  siCap_bump_samsung_0p4mmX1mm
	xEcapDTC_10_5    pkg_bump_ns_ew_10_5    pkg_bump_ns_ew_10_5_pkgPad    ref_gnd  siCap_bump_samsung_0p4mmX1mm
	xEcapDTC_10_6    pkg_bump_ns_ew_10_6    pkg_bump_ns_ew_10_6_pkgPad    ref_gnd  siCap_bump_samsung_0p4mmX1mm
	xEcapDTC_10_7    pkg_bump_ns_ew_10_7    pkg_bump_ns_ew_10_7_pkgPad    ref_gnd  siCap_bump_samsung_0p4mmX1mm
	xEcapDTC_11_0    pkg_bump_ns_ew_11_0    pkg_bump_ns_ew_11_0_pkgPad    ref_gnd  siCap_bump_samsung_0p4mmX1mm
	xEcapDTC_11_1    pkg_bump_ns_ew_11_1    pkg_bump_ns_ew_11_1_pkgPad    ref_gnd  siCap_bump_samsung_0p4mmX1mm
	xEcapDTC_11_2    pkg_bump_ns_ew_11_2    pkg_bump_ns_ew_11_2_pkgPad    ref_gnd  siCap_bump_samsung_0p4mmX1mm
	xEcapDTC_11_3    pkg_bump_ns_ew_11_3    pkg_bump_ns_ew_11_3_pkgPad    ref_gnd  siCap_bump_samsung_0p4mmX1mm
	xEcapDTC_11_4    pkg_bump_ns_ew_11_4    pkg_bump_ns_ew_11_4_pkgPad    ref_gnd  siCap_bump_samsung_0p4mmX1mm
	xEcapDTC_11_5    pkg_bump_ns_ew_11_5    pkg_bump_ns_ew_11_5_pkgPad    ref_gnd  siCap_bump_samsung_0p4mmX1mm
	xEcapDTC_11_6    pkg_bump_ns_ew_11_6    pkg_bump_ns_ew_11_6_pkgPad    ref_gnd  siCap_bump_samsung_0p4mmX1mm
	xEcapDTC_11_7    pkg_bump_ns_ew_11_7    pkg_bump_ns_ew_11_7_pkgPad    ref_gnd  siCap_bump_samsung_0p4mmX1mm
	xEcapDTC_12_0    pkg_bump_ns_ew_12_0    pkg_bump_ns_ew_12_0_pkgPad    ref_gnd  siCap_bump_samsung_0p4mmX1mm
	xEcapDTC_12_1    pkg_bump_ns_ew_12_1    pkg_bump_ns_ew_12_1_pkgPad    ref_gnd  siCap_bump_samsung_0p4mmX1mm
	xEcapDTC_12_2    pkg_bump_ns_ew_12_2    pkg_bump_ns_ew_12_2_pkgPad    ref_gnd  siCap_bump_samsung_0p4mmX1mm
	xEcapDTC_12_3    pkg_bump_ns_ew_12_3    pkg_bump_ns_ew_12_3_pkgPad    ref_gnd  siCap_bump_samsung_0p4mmX1mm
	xEcapDTC_12_4    pkg_bump_ns_ew_12_4    pkg_bump_ns_ew_12_4_pkgPad    ref_gnd  siCap_bump_samsung_0p4mmX1mm
	xEcapDTC_12_5    pkg_bump_ns_ew_12_5    pkg_bump_ns_ew_12_5_pkgPad    ref_gnd  siCap_bump_samsung_0p4mmX1mm
	xEcapDTC_12_6    pkg_bump_ns_ew_12_6    pkg_bump_ns_ew_12_6_pkgPad    ref_gnd  siCap_bump_samsung_0p4mmX1mm
	xEcapDTC_12_7    pkg_bump_ns_ew_12_7    pkg_bump_ns_ew_12_7_pkgPad    ref_gnd  siCap_bump_samsung_0p4mmX1mm
	xEcapDTC_13_0    pkg_bump_ns_ew_13_0    pkg_bump_ns_ew_13_0_pkgPad    ref_gnd  siCap_bump_samsung_0p4mmX1mm
	xEcapDTC_13_1    pkg_bump_ns_ew_13_1    pkg_bump_ns_ew_13_1_pkgPad    ref_gnd  siCap_bump_samsung_0p4mmX1mm
	xEcapDTC_13_2    pkg_bump_ns_ew_13_2    pkg_bump_ns_ew_13_2_pkgPad    ref_gnd  siCap_bump_samsung_0p4mmX1mm
	xEcapDTC_13_3    pkg_bump_ns_ew_13_3    pkg_bump_ns_ew_13_3_pkgPad    ref_gnd  siCap_bump_samsung_0p4mmX1mm
	xEcapDTC_13_4    pkg_bump_ns_ew_13_4    pkg_bump_ns_ew_13_4_pkgPad    ref_gnd  siCap_bump_samsung_0p4mmX1mm
	xEcapDTC_13_5    pkg_bump_ns_ew_13_5    pkg_bump_ns_ew_13_5_pkgPad    ref_gnd  siCap_bump_samsung_0p4mmX1mm
	xEcapDTC_13_6    pkg_bump_ns_ew_13_6    pkg_bump_ns_ew_13_6_pkgPad    ref_gnd  siCap_bump_samsung_0p4mmX1mm
	xEcapDTC_13_7    pkg_bump_ns_ew_13_7    pkg_bump_ns_ew_13_7_pkgPad    ref_gnd  siCap_bump_samsung_0p4mmX1mm
	xEcapDTC_14_0    pkg_bump_ns_ew_14_0    pkg_bump_ns_ew_14_0_pkgPad    ref_gnd  siCap_bump_samsung_0p4mmX1mm
	xEcapDTC_14_1    pkg_bump_ns_ew_14_1    pkg_bump_ns_ew_14_1_pkgPad    ref_gnd  siCap_bump_samsung_0p4mmX1mm
	xEcapDTC_14_2    pkg_bump_ns_ew_14_2    pkg_bump_ns_ew_14_2_pkgPad    ref_gnd  siCap_bump_samsung_0p4mmX1mm
	xEcapDTC_14_3    pkg_bump_ns_ew_14_3    pkg_bump_ns_ew_14_3_pkgPad    ref_gnd  siCap_bump_samsung_0p4mmX1mm
	xEcapDTC_14_4    pkg_bump_ns_ew_14_4    pkg_bump_ns_ew_14_4_pkgPad    ref_gnd  siCap_bump_samsung_0p4mmX1mm
	xEcapDTC_14_5    pkg_bump_ns_ew_14_5    pkg_bump_ns_ew_14_5_pkgPad    ref_gnd  siCap_bump_samsung_0p4mmX1mm
	xEcapDTC_14_6    pkg_bump_ns_ew_14_6    pkg_bump_ns_ew_14_6_pkgPad    ref_gnd  siCap_bump_samsung_0p4mmX1mm
	xEcapDTC_14_7    pkg_bump_ns_ew_14_7    pkg_bump_ns_ew_14_7_pkgPad    ref_gnd  siCap_bump_samsung_0p4mmX1mm
	xEcapDTC_15_0    pkg_bump_ns_ew_15_0    pkg_bump_ns_ew_15_0_pkgPad    ref_gnd  siCap_bump_samsung_0p4mmX1mm
	xEcapDTC_15_1    pkg_bump_ns_ew_15_1    pkg_bump_ns_ew_15_1_pkgPad    ref_gnd  siCap_bump_samsung_0p4mmX1mm
	xEcapDTC_15_2    pkg_bump_ns_ew_15_2    pkg_bump_ns_ew_15_2_pkgPad    ref_gnd  siCap_bump_samsung_0p4mmX1mm
	xEcapDTC_15_3    pkg_bump_ns_ew_15_3    pkg_bump_ns_ew_15_3_pkgPad    ref_gnd  siCap_bump_samsung_0p4mmX1mm
	xEcapDTC_15_4    pkg_bump_ns_ew_15_4    pkg_bump_ns_ew_15_4_pkgPad    ref_gnd  siCap_bump_samsung_0p4mmX1mm
	xEcapDTC_15_5    pkg_bump_ns_ew_15_5    pkg_bump_ns_ew_15_5_pkgPad    ref_gnd  siCap_bump_samsung_0p4mmX1mm
	xEcapDTC_15_6    pkg_bump_ns_ew_15_6    pkg_bump_ns_ew_15_6_pkgPad    ref_gnd  siCap_bump_samsung_0p4mmX1mm
	xEcapDTC_15_7    pkg_bump_ns_ew_15_7    pkg_bump_ns_ew_15_7_pkgPad    ref_gnd  siCap_bump_samsung_0p4mmX1mm
	xEcapDTC_16_0    pkg_bump_ns_ew_16_0    pkg_bump_ns_ew_16_0_pkgPad    ref_gnd  siCap_bump_samsung_0p4mmX1mm
	xEcapDTC_16_1    pkg_bump_ns_ew_16_1    pkg_bump_ns_ew_16_1_pkgPad    ref_gnd  siCap_bump_samsung_0p4mmX1mm
	xEcapDTC_16_2    pkg_bump_ns_ew_16_2    pkg_bump_ns_ew_16_2_pkgPad    ref_gnd  siCap_bump_samsung_0p4mmX1mm
	xEcapDTC_16_3    pkg_bump_ns_ew_16_3    pkg_bump_ns_ew_16_3_pkgPad    ref_gnd  siCap_bump_samsung_0p4mmX1mm
	xEcapDTC_16_4    pkg_bump_ns_ew_16_4    pkg_bump_ns_ew_16_4_pkgPad    ref_gnd  siCap_bump_samsung_0p4mmX1mm
	xEcapDTC_16_5    pkg_bump_ns_ew_16_5    pkg_bump_ns_ew_16_5_pkgPad    ref_gnd  siCap_bump_samsung_0p4mmX1mm
	xEcapDTC_16_6    pkg_bump_ns_ew_16_6    pkg_bump_ns_ew_16_6_pkgPad    ref_gnd  siCap_bump_samsung_0p4mmX1mm
	xEcapDTC_16_7    pkg_bump_ns_ew_16_7    pkg_bump_ns_ew_16_7_pkgPad    ref_gnd  siCap_bump_samsung_0p4mmX1mm
	xEcapDTC_17_0    pkg_bump_ns_ew_17_0    pkg_bump_ns_ew_17_0_pkgPad    ref_gnd  siCap_bump_samsung_0p4mmX1mm
	xEcapDTC_17_1    pkg_bump_ns_ew_17_1    pkg_bump_ns_ew_17_1_pkgPad    ref_gnd  siCap_bump_samsung_0p4mmX1mm
	xEcapDTC_17_2    pkg_bump_ns_ew_17_2    pkg_bump_ns_ew_17_2_pkgPad    ref_gnd  siCap_bump_samsung_0p4mmX1mm
	xEcapDTC_17_3    pkg_bump_ns_ew_17_3    pkg_bump_ns_ew_17_3_pkgPad    ref_gnd  siCap_bump_samsung_0p4mmX1mm
	xEcapDTC_17_4    pkg_bump_ns_ew_17_4    pkg_bump_ns_ew_17_4_pkgPad    ref_gnd  siCap_bump_samsung_0p4mmX1mm
	xEcapDTC_17_5    pkg_bump_ns_ew_17_5    pkg_bump_ns_ew_17_5_pkgPad    ref_gnd  siCap_bump_samsung_0p4mmX1mm
	xEcapDTC_17_6    pkg_bump_ns_ew_17_6    pkg_bump_ns_ew_17_6_pkgPad    ref_gnd  siCap_bump_samsung_0p4mmX1mm
	xEcapDTC_17_7    pkg_bump_ns_ew_17_7    pkg_bump_ns_ew_17_7_pkgPad    ref_gnd  siCap_bump_samsung_0p4mmX1mm
	xEcapDTC_18_0    pkg_bump_ns_ew_18_0    pkg_bump_ns_ew_18_0_pkgPad    ref_gnd  siCap_bump_samsung_0p4mmX1mm
	xEcapDTC_18_1    pkg_bump_ns_ew_18_1    pkg_bump_ns_ew_18_1_pkgPad    ref_gnd  siCap_bump_samsung_0p4mmX1mm
	xEcapDTC_18_2    pkg_bump_ns_ew_18_2    pkg_bump_ns_ew_18_2_pkgPad    ref_gnd  siCap_bump_samsung_0p4mmX1mm
	xEcapDTC_18_3    pkg_bump_ns_ew_18_3    pkg_bump_ns_ew_18_3_pkgPad    ref_gnd  siCap_bump_samsung_0p4mmX1mm
	xEcapDTC_18_4    pkg_bump_ns_ew_18_4    pkg_bump_ns_ew_18_4_pkgPad    ref_gnd  siCap_bump_samsung_0p4mmX1mm
	xEcapDTC_18_5    pkg_bump_ns_ew_18_5    pkg_bump_ns_ew_18_5_pkgPad    ref_gnd  siCap_bump_samsung_0p4mmX1mm
	xEcapDTC_18_6    pkg_bump_ns_ew_18_6    pkg_bump_ns_ew_18_6_pkgPad    ref_gnd  siCap_bump_samsung_0p4mmX1mm
	xEcapDTC_18_7    pkg_bump_ns_ew_18_7    pkg_bump_ns_ew_18_7_pkgPad    ref_gnd  siCap_bump_samsung_0p4mmX1mm
	xEcapDTC_19_0    pkg_bump_ns_ew_19_0    pkg_bump_ns_ew_19_0_pkgPad    ref_gnd  siCap_bump_samsung_0p4mmX1mm
	xEcapDTC_19_1    pkg_bump_ns_ew_19_1    pkg_bump_ns_ew_19_1_pkgPad    ref_gnd  siCap_bump_samsung_0p4mmX1mm
	xEcapDTC_19_2    pkg_bump_ns_ew_19_2    pkg_bump_ns_ew_19_2_pkgPad    ref_gnd  siCap_bump_samsung_0p4mmX1mm
	xEcapDTC_19_3    pkg_bump_ns_ew_19_3    pkg_bump_ns_ew_19_3_pkgPad    ref_gnd  siCap_bump_samsung_0p4mmX1mm
	xEcapDTC_19_4    pkg_bump_ns_ew_19_4    pkg_bump_ns_ew_19_4_pkgPad    ref_gnd  siCap_bump_samsung_0p4mmX1mm
	xEcapDTC_19_5    pkg_bump_ns_ew_19_5    pkg_bump_ns_ew_19_5_pkgPad    ref_gnd  siCap_bump_samsung_0p4mmX1mm
	xEcapDTC_19_6    pkg_bump_ns_ew_19_6    pkg_bump_ns_ew_19_6_pkgPad    ref_gnd  siCap_bump_samsung_0p4mmX1mm
	xEcapDTC_19_7    pkg_bump_ns_ew_19_7    pkg_bump_ns_ew_19_7_pkgPad    ref_gnd  siCap_bump_samsung_0p4mmX1mm
	xEcapDTC_20_0    pkg_bump_ns_ew_20_0    pkg_bump_ns_ew_20_0_pkgPad    ref_gnd  siCap_bump_samsung_0p4mmX1mm
	xEcapDTC_20_1    pkg_bump_ns_ew_20_1    pkg_bump_ns_ew_20_1_pkgPad    ref_gnd  siCap_bump_samsung_0p4mmX1mm
	xEcapDTC_20_2    pkg_bump_ns_ew_20_2    pkg_bump_ns_ew_20_2_pkgPad    ref_gnd  siCap_bump_samsung_0p4mmX1mm
	xEcapDTC_20_3    pkg_bump_ns_ew_20_3    pkg_bump_ns_ew_20_3_pkgPad    ref_gnd  siCap_bump_samsung_0p4mmX1mm
	xEcapDTC_20_4    pkg_bump_ns_ew_20_4    pkg_bump_ns_ew_20_4_pkgPad    ref_gnd  siCap_bump_samsung_0p4mmX1mm
	xEcapDTC_20_5    pkg_bump_ns_ew_20_5    pkg_bump_ns_ew_20_5_pkgPad    ref_gnd  siCap_bump_samsung_0p4mmX1mm
	xEcapDTC_20_6    pkg_bump_ns_ew_20_6    pkg_bump_ns_ew_20_6_pkgPad    ref_gnd  siCap_bump_samsung_0p4mmX1mm
	xEcapDTC_20_7    pkg_bump_ns_ew_20_7    pkg_bump_ns_ew_20_7_pkgPad    ref_gnd  siCap_bump_samsung_0p4mmX1mm
	xEcapDTC_21_0    pkg_bump_ns_ew_21_0    pkg_bump_ns_ew_21_0_pkgPad    ref_gnd  siCap_bump_samsung_0p4mmX1mm
	xEcapDTC_21_1    pkg_bump_ns_ew_21_1    pkg_bump_ns_ew_21_1_pkgPad    ref_gnd  siCap_bump_samsung_0p4mmX1mm
	xEcapDTC_21_2    pkg_bump_ns_ew_21_2    pkg_bump_ns_ew_21_2_pkgPad    ref_gnd  siCap_bump_samsung_0p4mmX1mm
	xEcapDTC_21_3    pkg_bump_ns_ew_21_3    pkg_bump_ns_ew_21_3_pkgPad    ref_gnd  siCap_bump_samsung_0p4mmX1mm
	xEcapDTC_21_4    pkg_bump_ns_ew_21_4    pkg_bump_ns_ew_21_4_pkgPad    ref_gnd  siCap_bump_samsung_0p4mmX1mm
	xEcapDTC_21_5    pkg_bump_ns_ew_21_5    pkg_bump_ns_ew_21_5_pkgPad    ref_gnd  siCap_bump_samsung_0p4mmX1mm
	xEcapDTC_21_6    pkg_bump_ns_ew_21_6    pkg_bump_ns_ew_21_6_pkgPad    ref_gnd  siCap_bump_samsung_0p4mmX1mm
	xEcapDTC_21_7    pkg_bump_ns_ew_21_7    pkg_bump_ns_ew_21_7_pkgPad    ref_gnd  siCap_bump_samsung_0p4mmX1mm
	xEcapDTC_22_0    pkg_bump_ns_ew_22_0    pkg_bump_ns_ew_22_0_pkgPad    ref_gnd  siCap_bump_samsung_0p4mmX1mm
	xEcapDTC_22_1    pkg_bump_ns_ew_22_1    pkg_bump_ns_ew_22_1_pkgPad    ref_gnd  siCap_bump_samsung_0p4mmX1mm
	xEcapDTC_22_2    pkg_bump_ns_ew_22_2    pkg_bump_ns_ew_22_2_pkgPad    ref_gnd  siCap_bump_samsung_0p4mmX1mm
	xEcapDTC_22_3    pkg_bump_ns_ew_22_3    pkg_bump_ns_ew_22_3_pkgPad    ref_gnd  siCap_bump_samsung_0p4mmX1mm
	xEcapDTC_22_4    pkg_bump_ns_ew_22_4    pkg_bump_ns_ew_22_4_pkgPad    ref_gnd  siCap_bump_samsung_0p4mmX1mm
	xEcapDTC_22_5    pkg_bump_ns_ew_22_5    pkg_bump_ns_ew_22_5_pkgPad    ref_gnd  siCap_bump_samsung_0p4mmX1mm
	xEcapDTC_22_6    pkg_bump_ns_ew_22_6    pkg_bump_ns_ew_22_6_pkgPad    ref_gnd  siCap_bump_samsung_0p4mmX1mm
	xEcapDTC_22_7    pkg_bump_ns_ew_22_7    pkg_bump_ns_ew_22_7_pkgPad    ref_gnd  siCap_bump_samsung_0p4mmX1mm
	xEcapDTC_23_0    pkg_bump_ns_ew_23_0    pkg_bump_ns_ew_23_0_pkgPad    ref_gnd  siCap_bump_samsung_0p4mmX1mm
	xEcapDTC_23_1    pkg_bump_ns_ew_23_1    pkg_bump_ns_ew_23_1_pkgPad    ref_gnd  siCap_bump_samsung_0p4mmX1mm
	xEcapDTC_23_2    pkg_bump_ns_ew_23_2    pkg_bump_ns_ew_23_2_pkgPad    ref_gnd  siCap_bump_samsung_0p4mmX1mm
	xEcapDTC_23_3    pkg_bump_ns_ew_23_3    pkg_bump_ns_ew_23_3_pkgPad    ref_gnd  siCap_bump_samsung_0p4mmX1mm
	xEcapDTC_23_4    pkg_bump_ns_ew_23_4    pkg_bump_ns_ew_23_4_pkgPad    ref_gnd  siCap_bump_samsung_0p4mmX1mm
	xEcapDTC_23_5    pkg_bump_ns_ew_23_5    pkg_bump_ns_ew_23_5_pkgPad    ref_gnd  siCap_bump_samsung_0p4mmX1mm
	xEcapDTC_23_6    pkg_bump_ns_ew_23_6    pkg_bump_ns_ew_23_6_pkgPad    ref_gnd  siCap_bump_samsung_0p4mmX1mm
	xEcapDTC_23_7    pkg_bump_ns_ew_23_7    pkg_bump_ns_ew_23_7_pkgPad    ref_gnd  siCap_bump_samsung_0p4mmX1mm
.endif

.if (is_bump_DTC == 0)
	r_bumpPadDummy_0_0     pkg_bump_ns_ew_0_0    pkg_bump_ns_ew_0_0_pkgPad      1.f
	r_bumpPadDummy_0_1     pkg_bump_ns_ew_0_1    pkg_bump_ns_ew_0_1_pkgPad      1.f
	r_bumpPadDummy_0_2     pkg_bump_ns_ew_0_2    pkg_bump_ns_ew_0_2_pkgPad      1.f
	r_bumpPadDummy_0_3     pkg_bump_ns_ew_0_3    pkg_bump_ns_ew_0_3_pkgPad      1.f
	r_bumpPadDummy_0_4     pkg_bump_ns_ew_0_4    pkg_bump_ns_ew_0_4_pkgPad      1.f
	r_bumpPadDummy_0_5     pkg_bump_ns_ew_0_5    pkg_bump_ns_ew_0_5_pkgPad      1.f
	r_bumpPadDummy_0_6     pkg_bump_ns_ew_0_6    pkg_bump_ns_ew_0_6_pkgPad      1.f
	r_bumpPadDummy_0_7     pkg_bump_ns_ew_0_7    pkg_bump_ns_ew_0_7_pkgPad      1.f
	r_bumpPadDummy_1_0     pkg_bump_ns_ew_1_0    pkg_bump_ns_ew_1_0_pkgPad      1.f
	r_bumpPadDummy_1_1     pkg_bump_ns_ew_1_1    pkg_bump_ns_ew_1_1_pkgPad      1.f
	r_bumpPadDummy_1_2     pkg_bump_ns_ew_1_2    pkg_bump_ns_ew_1_2_pkgPad      1.f
	r_bumpPadDummy_1_3     pkg_bump_ns_ew_1_3    pkg_bump_ns_ew_1_3_pkgPad      1.f
	r_bumpPadDummy_1_4     pkg_bump_ns_ew_1_4    pkg_bump_ns_ew_1_4_pkgPad      1.f
	r_bumpPadDummy_1_5     pkg_bump_ns_ew_1_5    pkg_bump_ns_ew_1_5_pkgPad      1.f
	r_bumpPadDummy_1_6     pkg_bump_ns_ew_1_6    pkg_bump_ns_ew_1_6_pkgPad      1.f
	r_bumpPadDummy_1_7     pkg_bump_ns_ew_1_7    pkg_bump_ns_ew_1_7_pkgPad      1.f
	r_bumpPadDummy_2_0     pkg_bump_ns_ew_2_0    pkg_bump_ns_ew_2_0_pkgPad      1.f
	r_bumpPadDummy_2_1     pkg_bump_ns_ew_2_1    pkg_bump_ns_ew_2_1_pkgPad      1.f
	r_bumpPadDummy_2_2     pkg_bump_ns_ew_2_2    pkg_bump_ns_ew_2_2_pkgPad      1.f
	r_bumpPadDummy_2_3     pkg_bump_ns_ew_2_3    pkg_bump_ns_ew_2_3_pkgPad      1.f
	r_bumpPadDummy_2_4     pkg_bump_ns_ew_2_4    pkg_bump_ns_ew_2_4_pkgPad      1.f
	r_bumpPadDummy_2_5     pkg_bump_ns_ew_2_5    pkg_bump_ns_ew_2_5_pkgPad      1.f
	r_bumpPadDummy_2_6     pkg_bump_ns_ew_2_6    pkg_bump_ns_ew_2_6_pkgPad      1.f
	r_bumpPadDummy_2_7     pkg_bump_ns_ew_2_7    pkg_bump_ns_ew_2_7_pkgPad      1.f
	r_bumpPadDummy_3_0     pkg_bump_ns_ew_3_0    pkg_bump_ns_ew_3_0_pkgPad      1.f
	r_bumpPadDummy_3_1     pkg_bump_ns_ew_3_1    pkg_bump_ns_ew_3_1_pkgPad      1.f
	r_bumpPadDummy_3_2     pkg_bump_ns_ew_3_2    pkg_bump_ns_ew_3_2_pkgPad      1.f
	r_bumpPadDummy_3_3     pkg_bump_ns_ew_3_3    pkg_bump_ns_ew_3_3_pkgPad      1.f
	r_bumpPadDummy_3_4     pkg_bump_ns_ew_3_4    pkg_bump_ns_ew_3_4_pkgPad      1.f
	r_bumpPadDummy_3_5     pkg_bump_ns_ew_3_5    pkg_bump_ns_ew_3_5_pkgPad      1.f
	r_bumpPadDummy_3_6     pkg_bump_ns_ew_3_6    pkg_bump_ns_ew_3_6_pkgPad      1.f
	r_bumpPadDummy_3_7     pkg_bump_ns_ew_3_7    pkg_bump_ns_ew_3_7_pkgPad      1.f
	r_bumpPadDummy_4_0     pkg_bump_ns_ew_4_0    pkg_bump_ns_ew_4_0_pkgPad      1.f
	r_bumpPadDummy_4_1     pkg_bump_ns_ew_4_1    pkg_bump_ns_ew_4_1_pkgPad      1.f
	r_bumpPadDummy_4_2     pkg_bump_ns_ew_4_2    pkg_bump_ns_ew_4_2_pkgPad      1.f
	r_bumpPadDummy_4_3     pkg_bump_ns_ew_4_3    pkg_bump_ns_ew_4_3_pkgPad      1.f
	r_bumpPadDummy_4_4     pkg_bump_ns_ew_4_4    pkg_bump_ns_ew_4_4_pkgPad      1.f
	r_bumpPadDummy_4_5     pkg_bump_ns_ew_4_5    pkg_bump_ns_ew_4_5_pkgPad      1.f
	r_bumpPadDummy_4_6     pkg_bump_ns_ew_4_6    pkg_bump_ns_ew_4_6_pkgPad      1.f
	r_bumpPadDummy_4_7     pkg_bump_ns_ew_4_7    pkg_bump_ns_ew_4_7_pkgPad      1.f
	r_bumpPadDummy_5_0     pkg_bump_ns_ew_5_0    pkg_bump_ns_ew_5_0_pkgPad      1.f
	r_bumpPadDummy_5_1     pkg_bump_ns_ew_5_1    pkg_bump_ns_ew_5_1_pkgPad      1.f
	r_bumpPadDummy_5_2     pkg_bump_ns_ew_5_2    pkg_bump_ns_ew_5_2_pkgPad      1.f
	r_bumpPadDummy_5_3     pkg_bump_ns_ew_5_3    pkg_bump_ns_ew_5_3_pkgPad      1.f
	r_bumpPadDummy_5_4     pkg_bump_ns_ew_5_4    pkg_bump_ns_ew_5_4_pkgPad      1.f
	r_bumpPadDummy_5_5     pkg_bump_ns_ew_5_5    pkg_bump_ns_ew_5_5_pkgPad      1.f
	r_bumpPadDummy_5_6     pkg_bump_ns_ew_5_6    pkg_bump_ns_ew_5_6_pkgPad      1.f
	r_bumpPadDummy_5_7     pkg_bump_ns_ew_5_7    pkg_bump_ns_ew_5_7_pkgPad      1.f
	r_bumpPadDummy_6_0     pkg_bump_ns_ew_6_0    pkg_bump_ns_ew_6_0_pkgPad      1.f
	r_bumpPadDummy_6_1     pkg_bump_ns_ew_6_1    pkg_bump_ns_ew_6_1_pkgPad      1.f
	r_bumpPadDummy_6_2     pkg_bump_ns_ew_6_2    pkg_bump_ns_ew_6_2_pkgPad      1.f
	r_bumpPadDummy_6_3     pkg_bump_ns_ew_6_3    pkg_bump_ns_ew_6_3_pkgPad      1.f
	r_bumpPadDummy_6_4     pkg_bump_ns_ew_6_4    pkg_bump_ns_ew_6_4_pkgPad      1.f
	r_bumpPadDummy_6_5     pkg_bump_ns_ew_6_5    pkg_bump_ns_ew_6_5_pkgPad      1.f
	r_bumpPadDummy_6_6     pkg_bump_ns_ew_6_6    pkg_bump_ns_ew_6_6_pkgPad      1.f
	r_bumpPadDummy_6_7     pkg_bump_ns_ew_6_7    pkg_bump_ns_ew_6_7_pkgPad      1.f
	r_bumpPadDummy_7_0     pkg_bump_ns_ew_7_0    pkg_bump_ns_ew_7_0_pkgPad      1.f
	r_bumpPadDummy_7_1     pkg_bump_ns_ew_7_1    pkg_bump_ns_ew_7_1_pkgPad      1.f
	r_bumpPadDummy_7_2     pkg_bump_ns_ew_7_2    pkg_bump_ns_ew_7_2_pkgPad      1.f
	r_bumpPadDummy_7_3     pkg_bump_ns_ew_7_3    pkg_bump_ns_ew_7_3_pkgPad      1.f
	r_bumpPadDummy_7_4     pkg_bump_ns_ew_7_4    pkg_bump_ns_ew_7_4_pkgPad      1.f
	r_bumpPadDummy_7_5     pkg_bump_ns_ew_7_5    pkg_bump_ns_ew_7_5_pkgPad      1.f
	r_bumpPadDummy_7_6     pkg_bump_ns_ew_7_6    pkg_bump_ns_ew_7_6_pkgPad      1.f
	r_bumpPadDummy_7_7     pkg_bump_ns_ew_7_7    pkg_bump_ns_ew_7_7_pkgPad      1.f
	r_bumpPadDummy_8_0     pkg_bump_ns_ew_8_0    pkg_bump_ns_ew_8_0_pkgPad      1.f
	r_bumpPadDummy_8_1     pkg_bump_ns_ew_8_1    pkg_bump_ns_ew_8_1_pkgPad      1.f
	r_bumpPadDummy_8_2     pkg_bump_ns_ew_8_2    pkg_bump_ns_ew_8_2_pkgPad      1.f
	r_bumpPadDummy_8_3     pkg_bump_ns_ew_8_3    pkg_bump_ns_ew_8_3_pkgPad      1.f
	r_bumpPadDummy_8_4     pkg_bump_ns_ew_8_4    pkg_bump_ns_ew_8_4_pkgPad      1.f
	r_bumpPadDummy_8_5     pkg_bump_ns_ew_8_5    pkg_bump_ns_ew_8_5_pkgPad      1.f
	r_bumpPadDummy_8_6     pkg_bump_ns_ew_8_6    pkg_bump_ns_ew_8_6_pkgPad      1.f
	r_bumpPadDummy_8_7     pkg_bump_ns_ew_8_7    pkg_bump_ns_ew_8_7_pkgPad      1.f
	r_bumpPadDummy_9_0     pkg_bump_ns_ew_9_0    pkg_bump_ns_ew_9_0_pkgPad      1.f
	r_bumpPadDummy_9_1     pkg_bump_ns_ew_9_1    pkg_bump_ns_ew_9_1_pkgPad      1.f
	r_bumpPadDummy_9_2     pkg_bump_ns_ew_9_2    pkg_bump_ns_ew_9_2_pkgPad      1.f
	r_bumpPadDummy_9_3     pkg_bump_ns_ew_9_3    pkg_bump_ns_ew_9_3_pkgPad      1.f
	r_bumpPadDummy_9_4     pkg_bump_ns_ew_9_4    pkg_bump_ns_ew_9_4_pkgPad      1.f
	r_bumpPadDummy_9_5     pkg_bump_ns_ew_9_5    pkg_bump_ns_ew_9_5_pkgPad      1.f
	r_bumpPadDummy_9_6     pkg_bump_ns_ew_9_6    pkg_bump_ns_ew_9_6_pkgPad      1.f
	r_bumpPadDummy_9_7     pkg_bump_ns_ew_9_7    pkg_bump_ns_ew_9_7_pkgPad      1.f
	r_bumpPadDummy_10_0    pkg_bump_ns_ew_10_0    pkg_bump_ns_ew_10_0_pkgPad    1.f
	r_bumpPadDummy_10_1    pkg_bump_ns_ew_10_1    pkg_bump_ns_ew_10_1_pkgPad    1.f
	r_bumpPadDummy_10_2    pkg_bump_ns_ew_10_2    pkg_bump_ns_ew_10_2_pkgPad    1.f
	r_bumpPadDummy_10_3    pkg_bump_ns_ew_10_3    pkg_bump_ns_ew_10_3_pkgPad    1.f
	r_bumpPadDummy_10_4    pkg_bump_ns_ew_10_4    pkg_bump_ns_ew_10_4_pkgPad    1.f
	r_bumpPadDummy_10_5    pkg_bump_ns_ew_10_5    pkg_bump_ns_ew_10_5_pkgPad    1.f
	r_bumpPadDummy_10_6    pkg_bump_ns_ew_10_6    pkg_bump_ns_ew_10_6_pkgPad    1.f
	r_bumpPadDummy_10_7    pkg_bump_ns_ew_10_7    pkg_bump_ns_ew_10_7_pkgPad    1.f
	r_bumpPadDummy_11_0    pkg_bump_ns_ew_11_0    pkg_bump_ns_ew_11_0_pkgPad    1.f
	r_bumpPadDummy_11_1    pkg_bump_ns_ew_11_1    pkg_bump_ns_ew_11_1_pkgPad    1.f
	r_bumpPadDummy_11_2    pkg_bump_ns_ew_11_2    pkg_bump_ns_ew_11_2_pkgPad    1.f
	r_bumpPadDummy_11_3    pkg_bump_ns_ew_11_3    pkg_bump_ns_ew_11_3_pkgPad    1.f
	r_bumpPadDummy_11_4    pkg_bump_ns_ew_11_4    pkg_bump_ns_ew_11_4_pkgPad    1.f
	r_bumpPadDummy_11_5    pkg_bump_ns_ew_11_5    pkg_bump_ns_ew_11_5_pkgPad    1.f
	r_bumpPadDummy_11_6    pkg_bump_ns_ew_11_6    pkg_bump_ns_ew_11_6_pkgPad    1.f
	r_bumpPadDummy_11_7    pkg_bump_ns_ew_11_7    pkg_bump_ns_ew_11_7_pkgPad    1.f
	r_bumpPadDummy_12_0    pkg_bump_ns_ew_12_0    pkg_bump_ns_ew_12_0_pkgPad    1.f
	r_bumpPadDummy_12_1    pkg_bump_ns_ew_12_1    pkg_bump_ns_ew_12_1_pkgPad    1.f
	r_bumpPadDummy_12_2    pkg_bump_ns_ew_12_2    pkg_bump_ns_ew_12_2_pkgPad    1.f
	r_bumpPadDummy_12_3    pkg_bump_ns_ew_12_3    pkg_bump_ns_ew_12_3_pkgPad    1.f
	r_bumpPadDummy_12_4    pkg_bump_ns_ew_12_4    pkg_bump_ns_ew_12_4_pkgPad    1.f
	r_bumpPadDummy_12_5    pkg_bump_ns_ew_12_5    pkg_bump_ns_ew_12_5_pkgPad    1.f
	r_bumpPadDummy_12_6    pkg_bump_ns_ew_12_6    pkg_bump_ns_ew_12_6_pkgPad    1.f
	r_bumpPadDummy_12_7    pkg_bump_ns_ew_12_7    pkg_bump_ns_ew_12_7_pkgPad    1.f
	r_bumpPadDummy_13_0    pkg_bump_ns_ew_13_0    pkg_bump_ns_ew_13_0_pkgPad    1.f
	r_bumpPadDummy_13_1    pkg_bump_ns_ew_13_1    pkg_bump_ns_ew_13_1_pkgPad    1.f
	r_bumpPadDummy_13_2    pkg_bump_ns_ew_13_2    pkg_bump_ns_ew_13_2_pkgPad    1.f
	r_bumpPadDummy_13_3    pkg_bump_ns_ew_13_3    pkg_bump_ns_ew_13_3_pkgPad    1.f
	r_bumpPadDummy_13_4    pkg_bump_ns_ew_13_4    pkg_bump_ns_ew_13_4_pkgPad    1.f
	r_bumpPadDummy_13_5    pkg_bump_ns_ew_13_5    pkg_bump_ns_ew_13_5_pkgPad    1.f
	r_bumpPadDummy_13_6    pkg_bump_ns_ew_13_6    pkg_bump_ns_ew_13_6_pkgPad    1.f
	r_bumpPadDummy_13_7    pkg_bump_ns_ew_13_7    pkg_bump_ns_ew_13_7_pkgPad    1.f
	r_bumpPadDummy_14_0    pkg_bump_ns_ew_14_0    pkg_bump_ns_ew_14_0_pkgPad    1.f
	r_bumpPadDummy_14_1    pkg_bump_ns_ew_14_1    pkg_bump_ns_ew_14_1_pkgPad    1.f
	r_bumpPadDummy_14_2    pkg_bump_ns_ew_14_2    pkg_bump_ns_ew_14_2_pkgPad    1.f
	r_bumpPadDummy_14_3    pkg_bump_ns_ew_14_3    pkg_bump_ns_ew_14_3_pkgPad    1.f
	r_bumpPadDummy_14_4    pkg_bump_ns_ew_14_4    pkg_bump_ns_ew_14_4_pkgPad    1.f
	r_bumpPadDummy_14_5    pkg_bump_ns_ew_14_5    pkg_bump_ns_ew_14_5_pkgPad    1.f
	r_bumpPadDummy_14_6    pkg_bump_ns_ew_14_6    pkg_bump_ns_ew_14_6_pkgPad    1.f
	r_bumpPadDummy_14_7    pkg_bump_ns_ew_14_7    pkg_bump_ns_ew_14_7_pkgPad    1.f
	r_bumpPadDummy_15_0    pkg_bump_ns_ew_15_0    pkg_bump_ns_ew_15_0_pkgPad    1.f
	r_bumpPadDummy_15_1    pkg_bump_ns_ew_15_1    pkg_bump_ns_ew_15_1_pkgPad    1.f
	r_bumpPadDummy_15_2    pkg_bump_ns_ew_15_2    pkg_bump_ns_ew_15_2_pkgPad    1.f
	r_bumpPadDummy_15_3    pkg_bump_ns_ew_15_3    pkg_bump_ns_ew_15_3_pkgPad    1.f
	r_bumpPadDummy_15_4    pkg_bump_ns_ew_15_4    pkg_bump_ns_ew_15_4_pkgPad    1.f
	r_bumpPadDummy_15_5    pkg_bump_ns_ew_15_5    pkg_bump_ns_ew_15_5_pkgPad    1.f
	r_bumpPadDummy_15_6    pkg_bump_ns_ew_15_6    pkg_bump_ns_ew_15_6_pkgPad    1.f
	r_bumpPadDummy_15_7    pkg_bump_ns_ew_15_7    pkg_bump_ns_ew_15_7_pkgPad    1.f
	r_bumpPadDummy_16_0    pkg_bump_ns_ew_16_0    pkg_bump_ns_ew_16_0_pkgPad    1.f
	r_bumpPadDummy_16_1    pkg_bump_ns_ew_16_1    pkg_bump_ns_ew_16_1_pkgPad    1.f
	r_bumpPadDummy_16_2    pkg_bump_ns_ew_16_2    pkg_bump_ns_ew_16_2_pkgPad    1.f
	r_bumpPadDummy_16_3    pkg_bump_ns_ew_16_3    pkg_bump_ns_ew_16_3_pkgPad    1.f
	r_bumpPadDummy_16_4    pkg_bump_ns_ew_16_4    pkg_bump_ns_ew_16_4_pkgPad    1.f
	r_bumpPadDummy_16_5    pkg_bump_ns_ew_16_5    pkg_bump_ns_ew_16_5_pkgPad    1.f
	r_bumpPadDummy_16_6    pkg_bump_ns_ew_16_6    pkg_bump_ns_ew_16_6_pkgPad    1.f
	r_bumpPadDummy_16_7    pkg_bump_ns_ew_16_7    pkg_bump_ns_ew_16_7_pkgPad    1.f
	r_bumpPadDummy_17_0    pkg_bump_ns_ew_17_0    pkg_bump_ns_ew_17_0_pkgPad    1.f
	r_bumpPadDummy_17_1    pkg_bump_ns_ew_17_1    pkg_bump_ns_ew_17_1_pkgPad    1.f
	r_bumpPadDummy_17_2    pkg_bump_ns_ew_17_2    pkg_bump_ns_ew_17_2_pkgPad    1.f
	r_bumpPadDummy_17_3    pkg_bump_ns_ew_17_3    pkg_bump_ns_ew_17_3_pkgPad    1.f
	r_bumpPadDummy_17_4    pkg_bump_ns_ew_17_4    pkg_bump_ns_ew_17_4_pkgPad    1.f
	r_bumpPadDummy_17_5    pkg_bump_ns_ew_17_5    pkg_bump_ns_ew_17_5_pkgPad    1.f
	r_bumpPadDummy_17_6    pkg_bump_ns_ew_17_6    pkg_bump_ns_ew_17_6_pkgPad    1.f
	r_bumpPadDummy_17_7    pkg_bump_ns_ew_17_7    pkg_bump_ns_ew_17_7_pkgPad    1.f
	r_bumpPadDummy_18_0    pkg_bump_ns_ew_18_0    pkg_bump_ns_ew_18_0_pkgPad    1.f
	r_bumpPadDummy_18_1    pkg_bump_ns_ew_18_1    pkg_bump_ns_ew_18_1_pkgPad    1.f
	r_bumpPadDummy_18_2    pkg_bump_ns_ew_18_2    pkg_bump_ns_ew_18_2_pkgPad    1.f
	r_bumpPadDummy_18_3    pkg_bump_ns_ew_18_3    pkg_bump_ns_ew_18_3_pkgPad    1.f
	r_bumpPadDummy_18_4    pkg_bump_ns_ew_18_4    pkg_bump_ns_ew_18_4_pkgPad    1.f
	r_bumpPadDummy_18_5    pkg_bump_ns_ew_18_5    pkg_bump_ns_ew_18_5_pkgPad    1.f
	r_bumpPadDummy_18_6    pkg_bump_ns_ew_18_6    pkg_bump_ns_ew_18_6_pkgPad    1.f
	r_bumpPadDummy_18_7    pkg_bump_ns_ew_18_7    pkg_bump_ns_ew_18_7_pkgPad    1.f
	r_bumpPadDummy_19_0    pkg_bump_ns_ew_19_0    pkg_bump_ns_ew_19_0_pkgPad    1.f
	r_bumpPadDummy_19_1    pkg_bump_ns_ew_19_1    pkg_bump_ns_ew_19_1_pkgPad    1.f
	r_bumpPadDummy_19_2    pkg_bump_ns_ew_19_2    pkg_bump_ns_ew_19_2_pkgPad    1.f
	r_bumpPadDummy_19_3    pkg_bump_ns_ew_19_3    pkg_bump_ns_ew_19_3_pkgPad    1.f
	r_bumpPadDummy_19_4    pkg_bump_ns_ew_19_4    pkg_bump_ns_ew_19_4_pkgPad    1.f
	r_bumpPadDummy_19_5    pkg_bump_ns_ew_19_5    pkg_bump_ns_ew_19_5_pkgPad    1.f
	r_bumpPadDummy_19_6    pkg_bump_ns_ew_19_6    pkg_bump_ns_ew_19_6_pkgPad    1.f
	r_bumpPadDummy_19_7    pkg_bump_ns_ew_19_7    pkg_bump_ns_ew_19_7_pkgPad    1.f
	r_bumpPadDummy_20_0    pkg_bump_ns_ew_20_0    pkg_bump_ns_ew_20_0_pkgPad    1.f
	r_bumpPadDummy_20_1    pkg_bump_ns_ew_20_1    pkg_bump_ns_ew_20_1_pkgPad    1.f
	r_bumpPadDummy_20_2    pkg_bump_ns_ew_20_2    pkg_bump_ns_ew_20_2_pkgPad    1.f
	r_bumpPadDummy_20_3    pkg_bump_ns_ew_20_3    pkg_bump_ns_ew_20_3_pkgPad    1.f
	r_bumpPadDummy_20_4    pkg_bump_ns_ew_20_4    pkg_bump_ns_ew_20_4_pkgPad    1.f
	r_bumpPadDummy_20_5    pkg_bump_ns_ew_20_5    pkg_bump_ns_ew_20_5_pkgPad    1.f
	r_bumpPadDummy_20_6    pkg_bump_ns_ew_20_6    pkg_bump_ns_ew_20_6_pkgPad    1.f
	r_bumpPadDummy_20_7    pkg_bump_ns_ew_20_7    pkg_bump_ns_ew_20_7_pkgPad    1.f
	r_bumpPadDummy_21_0    pkg_bump_ns_ew_21_0    pkg_bump_ns_ew_21_0_pkgPad    1.f
	r_bumpPadDummy_21_1    pkg_bump_ns_ew_21_1    pkg_bump_ns_ew_21_1_pkgPad    1.f
	r_bumpPadDummy_21_2    pkg_bump_ns_ew_21_2    pkg_bump_ns_ew_21_2_pkgPad    1.f
	r_bumpPadDummy_21_3    pkg_bump_ns_ew_21_3    pkg_bump_ns_ew_21_3_pkgPad    1.f
	r_bumpPadDummy_21_4    pkg_bump_ns_ew_21_4    pkg_bump_ns_ew_21_4_pkgPad    1.f
	r_bumpPadDummy_21_5    pkg_bump_ns_ew_21_5    pkg_bump_ns_ew_21_5_pkgPad    1.f
	r_bumpPadDummy_21_6    pkg_bump_ns_ew_21_6    pkg_bump_ns_ew_21_6_pkgPad    1.f
	r_bumpPadDummy_21_7    pkg_bump_ns_ew_21_7    pkg_bump_ns_ew_21_7_pkgPad    1.f
	r_bumpPadDummy_22_0    pkg_bump_ns_ew_22_0    pkg_bump_ns_ew_22_0_pkgPad    1.f
	r_bumpPadDummy_22_1    pkg_bump_ns_ew_22_1    pkg_bump_ns_ew_22_1_pkgPad    1.f
	r_bumpPadDummy_22_2    pkg_bump_ns_ew_22_2    pkg_bump_ns_ew_22_2_pkgPad    1.f
	r_bumpPadDummy_22_3    pkg_bump_ns_ew_22_3    pkg_bump_ns_ew_22_3_pkgPad    1.f
	r_bumpPadDummy_22_4    pkg_bump_ns_ew_22_4    pkg_bump_ns_ew_22_4_pkgPad    1.f
	r_bumpPadDummy_22_5    pkg_bump_ns_ew_22_5    pkg_bump_ns_ew_22_5_pkgPad    1.f
	r_bumpPadDummy_22_6    pkg_bump_ns_ew_22_6    pkg_bump_ns_ew_22_6_pkgPad    1.f
	r_bumpPadDummy_22_7    pkg_bump_ns_ew_22_7    pkg_bump_ns_ew_22_7_pkgPad    1.f
	r_bumpPadDummy_23_0    pkg_bump_ns_ew_23_0    pkg_bump_ns_ew_23_0_pkgPad    1.f
	r_bumpPadDummy_23_1    pkg_bump_ns_ew_23_1    pkg_bump_ns_ew_23_1_pkgPad    1.f
	r_bumpPadDummy_23_2    pkg_bump_ns_ew_23_2    pkg_bump_ns_ew_23_2_pkgPad    1.f
	r_bumpPadDummy_23_3    pkg_bump_ns_ew_23_3    pkg_bump_ns_ew_23_3_pkgPad    1.f
	r_bumpPadDummy_23_4    pkg_bump_ns_ew_23_4    pkg_bump_ns_ew_23_4_pkgPad    1.f
	r_bumpPadDummy_23_5    pkg_bump_ns_ew_23_5    pkg_bump_ns_ew_23_5_pkgPad    1.f
	r_bumpPadDummy_23_6    pkg_bump_ns_ew_23_6    pkg_bump_ns_ew_23_6_pkgPad    1.f
	r_bumpPadDummy_23_7    pkg_bump_ns_ew_23_7    pkg_bump_ns_ew_23_7_pkgPad    1.f
.endif

* Xblk_pkg	*** POR w/ 3x Ecap  	*** (SIwave 2025R2)
* + pkg_bump_ns_ew_0_0_pkgPad
* + pkg_bump_ns_ew_0_1_pkgPad
* + pkg_bump_ns_ew_0_2_pkgPad
* + pkg_bump_ns_ew_0_3_pkgPad
* + pkg_bump_ns_ew_0_4_pkgPad
* + pkg_bump_ns_ew_0_5_pkgPad
* + pkg_bump_ns_ew_0_6_pkgPad
* + pkg_bump_ns_ew_0_7_pkgPad
* + pkg_bump_ns_ew_1_0_pkgPad
* + pkg_bump_ns_ew_1_1_pkgPad
* + pkg_bump_ns_ew_1_2_pkgPad
* + pkg_bump_ns_ew_1_3_pkgPad
* + pkg_bump_ns_ew_1_4_pkgPad
* + pkg_bump_ns_ew_1_5_pkgPad
* + pkg_bump_ns_ew_1_6_pkgPad
* + pkg_bump_ns_ew_1_7_pkgPad
* + pkg_bump_ns_ew_2_0_pkgPad
* + pkg_bump_ns_ew_2_1_pkgPad
* + pkg_bump_ns_ew_2_2_pkgPad
* + pkg_bump_ns_ew_2_3_pkgPad
* + pkg_bump_ns_ew_2_4_pkgPad
* + pkg_bump_ns_ew_2_5_pkgPad
* + pkg_bump_ns_ew_2_6_pkgPad
* + pkg_bump_ns_ew_2_7_pkgPad
* + pkg_bump_ns_ew_3_0_pkgPad
* + pkg_bump_ns_ew_3_1_pkgPad
* + pkg_bump_ns_ew_3_2_pkgPad
* + pkg_bump_ns_ew_3_3_pkgPad
* + pkg_bump_ns_ew_3_4_pkgPad
* + pkg_bump_ns_ew_3_5_pkgPad
* + pkg_bump_ns_ew_3_6_pkgPad
* + pkg_bump_ns_ew_3_7_pkgPad
* + pkg_bump_ns_ew_4_0_pkgPad
* + pkg_bump_ns_ew_4_1_pkgPad
* + pkg_bump_ns_ew_4_2_pkgPad
* + pkg_bump_ns_ew_4_3_pkgPad
* + pkg_bump_ns_ew_4_4_pkgPad
* + pkg_bump_ns_ew_4_5_pkgPad
* + pkg_bump_ns_ew_4_6_pkgPad
* + pkg_bump_ns_ew_4_7_pkgPad
* + pkg_bump_ns_ew_5_0_pkgPad
* + pkg_bump_ns_ew_5_1_pkgPad
* + pkg_bump_ns_ew_5_2_pkgPad
* + pkg_bump_ns_ew_5_3_pkgPad
* + pkg_bump_ns_ew_5_4_pkgPad
* + pkg_bump_ns_ew_5_5_pkgPad
* + pkg_bump_ns_ew_5_6_pkgPad
* + pkg_bump_ns_ew_5_7_pkgPad
* + pkg_bump_ns_ew_6_0_pkgPad
* + pkg_bump_ns_ew_6_1_pkgPad
* + pkg_bump_ns_ew_6_2_pkgPad
* + pkg_bump_ns_ew_6_3_pkgPad
* + pkg_bump_ns_ew_6_4_pkgPad
* + pkg_bump_ns_ew_6_5_pkgPad
* + pkg_bump_ns_ew_6_6_pkgPad
* + pkg_bump_ns_ew_6_7_pkgPad
* + pkg_bump_ns_ew_7_0_pkgPad
* + pkg_bump_ns_ew_7_1_pkgPad
* + pkg_bump_ns_ew_7_2_pkgPad
* + pkg_bump_ns_ew_7_3_pkgPad
* + pkg_bump_ns_ew_7_4_pkgPad
* + pkg_bump_ns_ew_7_5_pkgPad
* + pkg_bump_ns_ew_7_6_pkgPad
* + pkg_bump_ns_ew_7_7_pkgPad
* + pkg_bump_ns_ew_8_0_pkgPad
* + pkg_bump_ns_ew_8_1_pkgPad
* + pkg_bump_ns_ew_8_2_pkgPad
* + pkg_bump_ns_ew_8_3_pkgPad
* + pkg_bump_ns_ew_8_4_pkgPad
* + pkg_bump_ns_ew_8_5_pkgPad
* + pkg_bump_ns_ew_8_6_pkgPad
* + pkg_bump_ns_ew_8_7_pkgPad
* + pkg_bump_ns_ew_9_0_pkgPad
* + pkg_bump_ns_ew_9_1_pkgPad
* + pkg_bump_ns_ew_9_2_pkgPad
* + pkg_bump_ns_ew_9_3_pkgPad
* + pkg_bump_ns_ew_9_4_pkgPad
* + pkg_bump_ns_ew_9_5_pkgPad
* + pkg_bump_ns_ew_9_6_pkgPad
* + pkg_bump_ns_ew_9_7_pkgPad
* + pkg_bump_ns_ew_10_0_pkgPad
* + pkg_bump_ns_ew_10_1_pkgPad
* + pkg_bump_ns_ew_10_2_pkgPad
* + pkg_bump_ns_ew_10_3_pkgPad
* + pkg_bump_ns_ew_10_4_pkgPad
* + pkg_bump_ns_ew_10_5_pkgPad
* + pkg_bump_ns_ew_10_6_pkgPad
* + pkg_bump_ns_ew_10_7_pkgPad
* + pkg_bump_ns_ew_11_0_pkgPad
* + pkg_bump_ns_ew_11_1_pkgPad
* + pkg_bump_ns_ew_11_2_pkgPad
* + pkg_bump_ns_ew_11_3_pkgPad
* + pkg_bump_ns_ew_11_4_pkgPad
* + pkg_bump_ns_ew_11_5_pkgPad
* + pkg_bump_ns_ew_11_6_pkgPad
* + pkg_bump_ns_ew_11_7_pkgPad
* + pkg_bump_ns_ew_12_0_pkgPad
* + pkg_bump_ns_ew_12_1_pkgPad
* + pkg_bump_ns_ew_12_2_pkgPad
* + pkg_bump_ns_ew_12_3_pkgPad
* + pkg_bump_ns_ew_12_4_pkgPad
* + pkg_bump_ns_ew_12_5_pkgPad
* + pkg_bump_ns_ew_12_6_pkgPad
* + pkg_bump_ns_ew_12_7_pkgPad
* + pkg_bump_ns_ew_13_0_pkgPad
* + pkg_bump_ns_ew_13_1_pkgPad
* + pkg_bump_ns_ew_13_2_pkgPad
* + pkg_bump_ns_ew_13_3_pkgPad
* + pkg_bump_ns_ew_13_4_pkgPad
* + pkg_bump_ns_ew_13_5_pkgPad
* + pkg_bump_ns_ew_13_6_pkgPad
* + pkg_bump_ns_ew_13_7_pkgPad
* + pkg_bump_ns_ew_14_0_pkgPad
* + pkg_bump_ns_ew_14_1_pkgPad
* + pkg_bump_ns_ew_14_2_pkgPad
* + pkg_bump_ns_ew_14_3_pkgPad
* + pkg_bump_ns_ew_14_4_pkgPad
* + pkg_bump_ns_ew_14_5_pkgPad
* + pkg_bump_ns_ew_14_6_pkgPad
* + pkg_bump_ns_ew_14_7_pkgPad
* + pkg_bump_ns_ew_15_0_pkgPad
* + pkg_bump_ns_ew_15_1_pkgPad
* + pkg_bump_ns_ew_15_2_pkgPad
* + pkg_bump_ns_ew_15_3_pkgPad
* + pkg_bump_ns_ew_15_4_pkgPad
* + pkg_bump_ns_ew_15_5_pkgPad
* + pkg_bump_ns_ew_15_6_pkgPad
* + pkg_bump_ns_ew_15_7_pkgPad
* + pkg_bump_ns_ew_16_0_pkgPad
* + pkg_bump_ns_ew_16_1_pkgPad
* + pkg_bump_ns_ew_16_2_pkgPad
* + pkg_bump_ns_ew_16_3_pkgPad
* + pkg_bump_ns_ew_16_4_pkgPad
* + pkg_bump_ns_ew_16_5_pkgPad
* + pkg_bump_ns_ew_16_6_pkgPad
* + pkg_bump_ns_ew_16_7_pkgPad
* + pkg_bump_ns_ew_17_0_pkgPad
* + pkg_bump_ns_ew_17_1_pkgPad
* + pkg_bump_ns_ew_17_2_pkgPad
* + pkg_bump_ns_ew_17_3_pkgPad
* + pkg_bump_ns_ew_17_4_pkgPad
* + pkg_bump_ns_ew_17_5_pkgPad
* + pkg_bump_ns_ew_17_6_pkgPad
* + pkg_bump_ns_ew_17_7_pkgPad
* + pkg_bump_ns_ew_18_0_pkgPad
* + pkg_bump_ns_ew_18_1_pkgPad
* + pkg_bump_ns_ew_18_2_pkgPad
* + pkg_bump_ns_ew_18_3_pkgPad
* + pkg_bump_ns_ew_18_4_pkgPad
* + pkg_bump_ns_ew_18_5_pkgPad
* + pkg_bump_ns_ew_18_6_pkgPad
* + pkg_bump_ns_ew_18_7_pkgPad
* + pkg_bump_ns_ew_19_0_pkgPad
* + pkg_bump_ns_ew_19_1_pkgPad
* + pkg_bump_ns_ew_19_2_pkgPad
* + pkg_bump_ns_ew_19_3_pkgPad
* + pkg_bump_ns_ew_19_4_pkgPad
* + pkg_bump_ns_ew_19_5_pkgPad
* + pkg_bump_ns_ew_19_6_pkgPad
* + pkg_bump_ns_ew_19_7_pkgPad
* + pkg_bump_ns_ew_20_0_pkgPad
* + pkg_bump_ns_ew_20_1_pkgPad
* + pkg_bump_ns_ew_20_2_pkgPad
* + pkg_bump_ns_ew_20_3_pkgPad
* + pkg_bump_ns_ew_20_4_pkgPad
* + pkg_bump_ns_ew_20_5_pkgPad
* + pkg_bump_ns_ew_20_6_pkgPad
* + pkg_bump_ns_ew_20_7_pkgPad
* + pkg_bump_ns_ew_21_0_pkgPad
* + pkg_bump_ns_ew_21_1_pkgPad
* + pkg_bump_ns_ew_21_2_pkgPad
* + pkg_bump_ns_ew_21_3_pkgPad
* + pkg_bump_ns_ew_21_4_pkgPad
* + pkg_bump_ns_ew_21_5_pkgPad
* + pkg_bump_ns_ew_21_6_pkgPad
* + pkg_bump_ns_ew_21_7_pkgPad
* + pkg_bump_ns_ew_22_0_pkgPad
* + pkg_bump_ns_ew_22_1_pkgPad
* + pkg_bump_ns_ew_22_2_pkgPad
* + pkg_bump_ns_ew_22_3_pkgPad
* + pkg_bump_ns_ew_22_4_pkgPad
* + pkg_bump_ns_ew_22_5_pkgPad
* + pkg_bump_ns_ew_22_6_pkgPad
* + pkg_bump_ns_ew_22_7_pkgPad
* + pkg_bump_ns_ew_23_0_pkgPad
* + pkg_bump_ns_ew_23_1_pkgPad
* + pkg_bump_ns_ew_23_2_pkgPad
* + pkg_bump_ns_ew_23_3_pkgPad
* + pkg_bump_ns_ew_23_4_pkgPad
* + pkg_bump_ns_ew_23_5_pkgPad
* + pkg_bump_ns_ew_23_6_pkgPad
* + pkg_bump_ns_ew_23_7_pkgPad
* + bga_3_7
* + bga_2_7
* + bga_1_7
* + bga_0_7
* + bga_3_6
* + bga_2_6
* + bga_1_6
* + bga_0_6
* + bga_3_5
* + bga_2_5
* + bga_1_5
* + bga_0_5
* + bga_3_4
* + bga_2_4
* + bga_1_4
* + bga_0_4
* + bga_3_3
* + bga_2_3
* + bga_1_3
* + bga_0_3
* + bga_3_2
* + bga_2_2
* + bga_1_2
* + bga_0_2
* + bga_3_1
* + bga_2_1
* + bga_1_1
* + bga_0_1
* + bga_3_0
* + bga_2_0
* + bga_1_0
* + bga_0_0
* + bga_OUT_0_1
* + bga_OUT_0_2
* + bga_OUT_0_3
* + bga_OUT_0_4
* + bga_OUT_1_1
* + bga_OUT_1_2
* + bga_OUT_1_3
* + bga_OUT_1_4
* + pkge_Ecap1_2x2mm_1
* + pkge_Ecap1_2x2mm_2
* + pkge_Ecap2_2x2mm_1
* + pkge_Ecap2_2x2mm_2
* + pkge_Ecap3_2x2mm_1
* + pkge_Ecap3_2x2mm_2
* + ref_gnd
* + NNE_Mammoth_PKG_NNE_MAM_eCap_dCap_cutout_250715_jgwei_die24x8_BGA40part_251117_redu_IdEM

Xblk_pkg		*** opt 1B, or 1C,  w/ 4x Ecap (not fully compatible with 5x Ecap layout extraction, 2025R2)
+ pkg_bump_ns_ew_0_0_pkgPad
+ pkg_bump_ns_ew_0_1_pkgPad
+ pkg_bump_ns_ew_0_2_pkgPad
+ pkg_bump_ns_ew_0_3_pkgPad
+ pkg_bump_ns_ew_0_4_pkgPad
+ pkg_bump_ns_ew_0_5_pkgPad
+ pkg_bump_ns_ew_0_6_pkgPad
+ pkg_bump_ns_ew_0_7_pkgPad
+ pkg_bump_ns_ew_1_0_pkgPad
+ pkg_bump_ns_ew_1_1_pkgPad
+ pkg_bump_ns_ew_1_2_pkgPad
+ pkg_bump_ns_ew_1_3_pkgPad
+ pkg_bump_ns_ew_1_4_pkgPad
+ pkg_bump_ns_ew_1_5_pkgPad
+ pkg_bump_ns_ew_1_6_pkgPad
+ pkg_bump_ns_ew_1_7_pkgPad
+ pkg_bump_ns_ew_2_0_pkgPad
+ pkg_bump_ns_ew_2_1_pkgPad
+ pkg_bump_ns_ew_2_2_pkgPad
+ pkg_bump_ns_ew_2_3_pkgPad
+ pkg_bump_ns_ew_2_4_pkgPad
+ pkg_bump_ns_ew_2_5_pkgPad
+ pkg_bump_ns_ew_2_6_pkgPad
+ pkg_bump_ns_ew_2_7_pkgPad
+ pkg_bump_ns_ew_3_0_pkgPad
+ pkg_bump_ns_ew_3_1_pkgPad
+ pkg_bump_ns_ew_3_2_pkgPad
+ pkg_bump_ns_ew_3_3_pkgPad
+ pkg_bump_ns_ew_3_4_pkgPad
+ pkg_bump_ns_ew_3_5_pkgPad
+ pkg_bump_ns_ew_3_6_pkgPad
+ pkg_bump_ns_ew_3_7_pkgPad
+ pkg_bump_ns_ew_4_0_pkgPad
+ pkg_bump_ns_ew_4_1_pkgPad
+ pkg_bump_ns_ew_4_2_pkgPad
+ pkg_bump_ns_ew_4_3_pkgPad
+ pkg_bump_ns_ew_4_4_pkgPad
+ pkg_bump_ns_ew_4_5_pkgPad
+ pkg_bump_ns_ew_4_6_pkgPad
+ pkg_bump_ns_ew_4_7_pkgPad
+ pkg_bump_ns_ew_5_0_pkgPad
+ pkg_bump_ns_ew_5_1_pkgPad
+ pkg_bump_ns_ew_5_2_pkgPad
+ pkg_bump_ns_ew_5_3_pkgPad
+ pkg_bump_ns_ew_5_4_pkgPad
+ pkg_bump_ns_ew_5_5_pkgPad
+ pkg_bump_ns_ew_5_6_pkgPad
+ pkg_bump_ns_ew_5_7_pkgPad
+ pkg_bump_ns_ew_6_0_pkgPad
+ pkg_bump_ns_ew_6_1_pkgPad
+ pkg_bump_ns_ew_6_2_pkgPad
+ pkg_bump_ns_ew_6_3_pkgPad
+ pkg_bump_ns_ew_6_4_pkgPad
+ pkg_bump_ns_ew_6_5_pkgPad
+ pkg_bump_ns_ew_6_6_pkgPad
+ pkg_bump_ns_ew_6_7_pkgPad
+ pkg_bump_ns_ew_7_0_pkgPad
+ pkg_bump_ns_ew_7_1_pkgPad
+ pkg_bump_ns_ew_7_2_pkgPad
+ pkg_bump_ns_ew_7_3_pkgPad
+ pkg_bump_ns_ew_7_4_pkgPad
+ pkg_bump_ns_ew_7_5_pkgPad
+ pkg_bump_ns_ew_7_6_pkgPad
+ pkg_bump_ns_ew_7_7_pkgPad
+ pkg_bump_ns_ew_8_0_pkgPad
+ pkg_bump_ns_ew_8_1_pkgPad
+ pkg_bump_ns_ew_8_2_pkgPad
+ pkg_bump_ns_ew_8_3_pkgPad
+ pkg_bump_ns_ew_8_4_pkgPad
+ pkg_bump_ns_ew_8_5_pkgPad
+ pkg_bump_ns_ew_8_6_pkgPad
+ pkg_bump_ns_ew_8_7_pkgPad
+ pkg_bump_ns_ew_9_0_pkgPad
+ pkg_bump_ns_ew_9_1_pkgPad
+ pkg_bump_ns_ew_9_2_pkgPad
+ pkg_bump_ns_ew_9_3_pkgPad
+ pkg_bump_ns_ew_9_4_pkgPad
+ pkg_bump_ns_ew_9_5_pkgPad
+ pkg_bump_ns_ew_9_6_pkgPad
+ pkg_bump_ns_ew_9_7_pkgPad
+ pkg_bump_ns_ew_10_0_pkgPad
+ pkg_bump_ns_ew_10_1_pkgPad
+ pkg_bump_ns_ew_10_2_pkgPad
+ pkg_bump_ns_ew_10_3_pkgPad
+ pkg_bump_ns_ew_10_4_pkgPad
+ pkg_bump_ns_ew_10_5_pkgPad
+ pkg_bump_ns_ew_10_6_pkgPad
+ pkg_bump_ns_ew_10_7_pkgPad
+ pkg_bump_ns_ew_11_0_pkgPad
+ pkg_bump_ns_ew_11_1_pkgPad
+ pkg_bump_ns_ew_11_2_pkgPad
+ pkg_bump_ns_ew_11_3_pkgPad
+ pkg_bump_ns_ew_11_4_pkgPad
+ pkg_bump_ns_ew_11_5_pkgPad
+ pkg_bump_ns_ew_11_6_pkgPad
+ pkg_bump_ns_ew_11_7_pkgPad
+ pkg_bump_ns_ew_12_0_pkgPad
+ pkg_bump_ns_ew_12_1_pkgPad
+ pkg_bump_ns_ew_12_2_pkgPad
+ pkg_bump_ns_ew_12_3_pkgPad
+ pkg_bump_ns_ew_12_4_pkgPad
+ pkg_bump_ns_ew_12_5_pkgPad
+ pkg_bump_ns_ew_12_6_pkgPad
+ pkg_bump_ns_ew_12_7_pkgPad
+ pkg_bump_ns_ew_13_0_pkgPad
+ pkg_bump_ns_ew_13_1_pkgPad
+ pkg_bump_ns_ew_13_2_pkgPad
+ pkg_bump_ns_ew_13_3_pkgPad
+ pkg_bump_ns_ew_13_4_pkgPad
+ pkg_bump_ns_ew_13_5_pkgPad
+ pkg_bump_ns_ew_13_6_pkgPad
+ pkg_bump_ns_ew_13_7_pkgPad
+ pkg_bump_ns_ew_14_0_pkgPad
+ pkg_bump_ns_ew_14_1_pkgPad
+ pkg_bump_ns_ew_14_2_pkgPad
+ pkg_bump_ns_ew_14_3_pkgPad
+ pkg_bump_ns_ew_14_4_pkgPad
+ pkg_bump_ns_ew_14_5_pkgPad
+ pkg_bump_ns_ew_14_6_pkgPad
+ pkg_bump_ns_ew_14_7_pkgPad
+ pkg_bump_ns_ew_15_0_pkgPad
+ pkg_bump_ns_ew_15_1_pkgPad
+ pkg_bump_ns_ew_15_2_pkgPad
+ pkg_bump_ns_ew_15_3_pkgPad
+ pkg_bump_ns_ew_15_4_pkgPad
+ pkg_bump_ns_ew_15_5_pkgPad
+ pkg_bump_ns_ew_15_6_pkgPad
+ pkg_bump_ns_ew_15_7_pkgPad
+ pkg_bump_ns_ew_16_0_pkgPad
+ pkg_bump_ns_ew_16_1_pkgPad
+ pkg_bump_ns_ew_16_2_pkgPad
+ pkg_bump_ns_ew_16_3_pkgPad
+ pkg_bump_ns_ew_16_4_pkgPad
+ pkg_bump_ns_ew_16_5_pkgPad
+ pkg_bump_ns_ew_16_6_pkgPad
+ pkg_bump_ns_ew_16_7_pkgPad
+ pkg_bump_ns_ew_17_0_pkgPad
+ pkg_bump_ns_ew_17_1_pkgPad
+ pkg_bump_ns_ew_17_2_pkgPad
+ pkg_bump_ns_ew_17_3_pkgPad
+ pkg_bump_ns_ew_17_4_pkgPad
+ pkg_bump_ns_ew_17_5_pkgPad
+ pkg_bump_ns_ew_17_6_pkgPad
+ pkg_bump_ns_ew_17_7_pkgPad
+ pkg_bump_ns_ew_18_0_pkgPad
+ pkg_bump_ns_ew_18_1_pkgPad
+ pkg_bump_ns_ew_18_2_pkgPad
+ pkg_bump_ns_ew_18_3_pkgPad
+ pkg_bump_ns_ew_18_4_pkgPad
+ pkg_bump_ns_ew_18_5_pkgPad
+ pkg_bump_ns_ew_18_6_pkgPad
+ pkg_bump_ns_ew_18_7_pkgPad
+ pkg_bump_ns_ew_19_0_pkgPad
+ pkg_bump_ns_ew_19_1_pkgPad
+ pkg_bump_ns_ew_19_2_pkgPad
+ pkg_bump_ns_ew_19_3_pkgPad
+ pkg_bump_ns_ew_19_4_pkgPad
+ pkg_bump_ns_ew_19_5_pkgPad
+ pkg_bump_ns_ew_19_6_pkgPad
+ pkg_bump_ns_ew_19_7_pkgPad
+ pkg_bump_ns_ew_20_0_pkgPad
+ pkg_bump_ns_ew_20_1_pkgPad
+ pkg_bump_ns_ew_20_2_pkgPad
+ pkg_bump_ns_ew_20_3_pkgPad
+ pkg_bump_ns_ew_20_4_pkgPad
+ pkg_bump_ns_ew_20_5_pkgPad
+ pkg_bump_ns_ew_20_6_pkgPad
+ pkg_bump_ns_ew_20_7_pkgPad
+ pkg_bump_ns_ew_21_0_pkgPad
+ pkg_bump_ns_ew_21_1_pkgPad
+ pkg_bump_ns_ew_21_2_pkgPad
+ pkg_bump_ns_ew_21_3_pkgPad
+ pkg_bump_ns_ew_21_4_pkgPad
+ pkg_bump_ns_ew_21_5_pkgPad
+ pkg_bump_ns_ew_21_6_pkgPad
+ pkg_bump_ns_ew_21_7_pkgPad
+ pkg_bump_ns_ew_22_0_pkgPad
+ pkg_bump_ns_ew_22_1_pkgPad
+ pkg_bump_ns_ew_22_2_pkgPad
+ pkg_bump_ns_ew_22_3_pkgPad
+ pkg_bump_ns_ew_22_4_pkgPad
+ pkg_bump_ns_ew_22_5_pkgPad
+ pkg_bump_ns_ew_22_6_pkgPad
+ pkg_bump_ns_ew_22_7_pkgPad
+ pkg_bump_ns_ew_23_0_pkgPad
+ pkg_bump_ns_ew_23_1_pkgPad
+ pkg_bump_ns_ew_23_2_pkgPad
+ pkg_bump_ns_ew_23_3_pkgPad
+ pkg_bump_ns_ew_23_4_pkgPad
+ pkg_bump_ns_ew_23_5_pkgPad
+ pkg_bump_ns_ew_23_6_pkgPad
+ pkg_bump_ns_ew_23_7_pkgPad
+ bga_3_7
+ bga_2_7
+ bga_1_7
+ bga_0_7
+ bga_3_6
+ bga_2_6
+ bga_1_6
+ bga_0_6
+ bga_3_5
+ bga_2_5
+ bga_1_5
+ bga_0_5
+ bga_3_4
+ bga_2_4
+ bga_1_4
+ bga_0_4
+ bga_3_3
+ bga_2_3
+ bga_1_3
+ bga_0_3
+ bga_3_2
+ bga_2_2
+ bga_1_2
+ bga_0_2
+ bga_3_1
+ bga_2_1
+ bga_1_1
+ bga_0_1
+ bga_3_0
+ bga_2_0
+ bga_1_0
+ bga_0_0
+ bga_OUT_0_1
+ bga_OUT_0_2
+ bga_OUT_0_3
+ bga_OUT_0_4
+ bga_OUT_1_1
+ bga_OUT_1_2
+ bga_OUT_1_3
+ bga_OUT_1_4
+ pkge_Ecap1_2x2mm_1
+ pkge_Ecap1_2x2mm_2
+ pkge_Ecap2_2x2mm_1
+ pkge_Ecap2_2x2mm_2
+ pkge_Ecap3_2x2mm_1
+ pkge_Ecap3_2x2mm_2
+ pkge_Ecap4_2x2mm_1
+ pkge_Ecap4_2x2mm_2
+ ref_gnd
* + nne_only_mam_ecap_120624_1_1b_251123_odb_cut_NNE_bump24x8_BGA40part_IdEM
+ NNE_only_MAM_ECAP_120624_1_1C_251205_2025R1_IdEM				*** POR 251210
* + NNE_only_MAM_ECAP_120624_1_1C_251205_2025R1_redu_DSC_Opt3_IdEM
* + NNE_only_MAM_ECAP_120624_1_1C_251205_2025R1_redu_DSC_Opt1_IdEM
* + NNE_only_MAM_ECAP_120624_1_1C_251205_2025R1_redu_DSC_Opt4_IdEM
* + NNE_only_MAM_ECAP_120624_1_1C_251205_2025R1_core400um_IdEM
* + NNE_only_MAM_ECAP_120624_1_1C_H65_251209_uVia65um_2025R1_IdEM
* + NNE_only_MAM_ECAP_120624_1_1C_251205_2025R1_noMLCC_IdEM
* + NNE_pkg_260101_Andes_2024_R2_HFSS_PI_modif_IdEM

* Xblk_pkg		*** pkg w/ 12x 1x1mm Ecap 2025R2)
* + pkg_bump_ns_ew_0_0_pkgPad
* + pkg_bump_ns_ew_0_1_pkgPad
* + pkg_bump_ns_ew_0_2_pkgPad
* + pkg_bump_ns_ew_0_3_pkgPad
* + pkg_bump_ns_ew_0_4_pkgPad
* + pkg_bump_ns_ew_0_5_pkgPad
* + pkg_bump_ns_ew_0_6_pkgPad
* + pkg_bump_ns_ew_0_7_pkgPad
* + pkg_bump_ns_ew_1_0_pkgPad
* + pkg_bump_ns_ew_1_1_pkgPad
* + pkg_bump_ns_ew_1_2_pkgPad
* + pkg_bump_ns_ew_1_3_pkgPad
* + pkg_bump_ns_ew_1_4_pkgPad
* + pkg_bump_ns_ew_1_5_pkgPad
* + pkg_bump_ns_ew_1_6_pkgPad
* + pkg_bump_ns_ew_1_7_pkgPad
* + pkg_bump_ns_ew_2_0_pkgPad
* + pkg_bump_ns_ew_2_1_pkgPad
* + pkg_bump_ns_ew_2_2_pkgPad
* + pkg_bump_ns_ew_2_3_pkgPad
* + pkg_bump_ns_ew_2_4_pkgPad
* + pkg_bump_ns_ew_2_5_pkgPad
* + pkg_bump_ns_ew_2_6_pkgPad
* + pkg_bump_ns_ew_2_7_pkgPad
* + pkg_bump_ns_ew_3_0_pkgPad
* + pkg_bump_ns_ew_3_1_pkgPad
* + pkg_bump_ns_ew_3_2_pkgPad
* + pkg_bump_ns_ew_3_3_pkgPad
* + pkg_bump_ns_ew_3_4_pkgPad
* + pkg_bump_ns_ew_3_5_pkgPad
* + pkg_bump_ns_ew_3_6_pkgPad
* + pkg_bump_ns_ew_3_7_pkgPad
* + pkg_bump_ns_ew_4_0_pkgPad
* + pkg_bump_ns_ew_4_1_pkgPad
* + pkg_bump_ns_ew_4_2_pkgPad
* + pkg_bump_ns_ew_4_3_pkgPad
* + pkg_bump_ns_ew_4_4_pkgPad
* + pkg_bump_ns_ew_4_5_pkgPad
* + pkg_bump_ns_ew_4_6_pkgPad
* + pkg_bump_ns_ew_4_7_pkgPad
* + pkg_bump_ns_ew_5_0_pkgPad
* + pkg_bump_ns_ew_5_1_pkgPad
* + pkg_bump_ns_ew_5_2_pkgPad
* + pkg_bump_ns_ew_5_3_pkgPad
* + pkg_bump_ns_ew_5_4_pkgPad
* + pkg_bump_ns_ew_5_5_pkgPad
* + pkg_bump_ns_ew_5_6_pkgPad
* + pkg_bump_ns_ew_5_7_pkgPad
* + pkg_bump_ns_ew_6_0_pkgPad
* + pkg_bump_ns_ew_6_1_pkgPad
* + pkg_bump_ns_ew_6_2_pkgPad
* + pkg_bump_ns_ew_6_3_pkgPad
* + pkg_bump_ns_ew_6_4_pkgPad
* + pkg_bump_ns_ew_6_5_pkgPad
* + pkg_bump_ns_ew_6_6_pkgPad
* + pkg_bump_ns_ew_6_7_pkgPad
* + pkg_bump_ns_ew_7_0_pkgPad
* + pkg_bump_ns_ew_7_1_pkgPad
* + pkg_bump_ns_ew_7_2_pkgPad
* + pkg_bump_ns_ew_7_3_pkgPad
* + pkg_bump_ns_ew_7_4_pkgPad
* + pkg_bump_ns_ew_7_5_pkgPad
* + pkg_bump_ns_ew_7_6_pkgPad
* + pkg_bump_ns_ew_7_7_pkgPad
* + pkg_bump_ns_ew_8_0_pkgPad
* + pkg_bump_ns_ew_8_1_pkgPad
* + pkg_bump_ns_ew_8_2_pkgPad
* + pkg_bump_ns_ew_8_3_pkgPad
* + pkg_bump_ns_ew_8_4_pkgPad
* + pkg_bump_ns_ew_8_5_pkgPad
* + pkg_bump_ns_ew_8_6_pkgPad
* + pkg_bump_ns_ew_8_7_pkgPad
* + pkg_bump_ns_ew_9_0_pkgPad
* + pkg_bump_ns_ew_9_1_pkgPad
* + pkg_bump_ns_ew_9_2_pkgPad
* + pkg_bump_ns_ew_9_3_pkgPad
* + pkg_bump_ns_ew_9_4_pkgPad
* + pkg_bump_ns_ew_9_5_pkgPad
* + pkg_bump_ns_ew_9_6_pkgPad
* + pkg_bump_ns_ew_9_7_pkgPad
* + pkg_bump_ns_ew_10_0_pkgPad
* + pkg_bump_ns_ew_10_1_pkgPad
* + pkg_bump_ns_ew_10_2_pkgPad
* + pkg_bump_ns_ew_10_3_pkgPad
* + pkg_bump_ns_ew_10_4_pkgPad
* + pkg_bump_ns_ew_10_5_pkgPad
* + pkg_bump_ns_ew_10_6_pkgPad
* + pkg_bump_ns_ew_10_7_pkgPad
* + pkg_bump_ns_ew_11_0_pkgPad
* + pkg_bump_ns_ew_11_1_pkgPad
* + pkg_bump_ns_ew_11_2_pkgPad
* + pkg_bump_ns_ew_11_3_pkgPad
* + pkg_bump_ns_ew_11_4_pkgPad
* + pkg_bump_ns_ew_11_5_pkgPad
* + pkg_bump_ns_ew_11_6_pkgPad
* + pkg_bump_ns_ew_11_7_pkgPad
* + pkg_bump_ns_ew_12_0_pkgPad
* + pkg_bump_ns_ew_12_1_pkgPad
* + pkg_bump_ns_ew_12_2_pkgPad
* + pkg_bump_ns_ew_12_3_pkgPad
* + pkg_bump_ns_ew_12_4_pkgPad
* + pkg_bump_ns_ew_12_5_pkgPad
* + pkg_bump_ns_ew_12_6_pkgPad
* + pkg_bump_ns_ew_12_7_pkgPad
* + pkg_bump_ns_ew_13_0_pkgPad
* + pkg_bump_ns_ew_13_1_pkgPad
* + pkg_bump_ns_ew_13_2_pkgPad
* + pkg_bump_ns_ew_13_3_pkgPad
* + pkg_bump_ns_ew_13_4_pkgPad
* + pkg_bump_ns_ew_13_5_pkgPad
* + pkg_bump_ns_ew_13_6_pkgPad
* + pkg_bump_ns_ew_13_7_pkgPad
* + pkg_bump_ns_ew_14_0_pkgPad
* + pkg_bump_ns_ew_14_1_pkgPad
* + pkg_bump_ns_ew_14_2_pkgPad
* + pkg_bump_ns_ew_14_3_pkgPad
* + pkg_bump_ns_ew_14_4_pkgPad
* + pkg_bump_ns_ew_14_5_pkgPad
* + pkg_bump_ns_ew_14_6_pkgPad
* + pkg_bump_ns_ew_14_7_pkgPad
* + pkg_bump_ns_ew_15_0_pkgPad
* + pkg_bump_ns_ew_15_1_pkgPad
* + pkg_bump_ns_ew_15_2_pkgPad
* + pkg_bump_ns_ew_15_3_pkgPad
* + pkg_bump_ns_ew_15_4_pkgPad
* + pkg_bump_ns_ew_15_5_pkgPad
* + pkg_bump_ns_ew_15_6_pkgPad
* + pkg_bump_ns_ew_15_7_pkgPad
* + pkg_bump_ns_ew_16_0_pkgPad
* + pkg_bump_ns_ew_16_1_pkgPad
* + pkg_bump_ns_ew_16_2_pkgPad
* + pkg_bump_ns_ew_16_3_pkgPad
* + pkg_bump_ns_ew_16_4_pkgPad
* + pkg_bump_ns_ew_16_5_pkgPad
* + pkg_bump_ns_ew_16_6_pkgPad
* + pkg_bump_ns_ew_16_7_pkgPad
* + pkg_bump_ns_ew_17_0_pkgPad
* + pkg_bump_ns_ew_17_1_pkgPad
* + pkg_bump_ns_ew_17_2_pkgPad
* + pkg_bump_ns_ew_17_3_pkgPad
* + pkg_bump_ns_ew_17_4_pkgPad
* + pkg_bump_ns_ew_17_5_pkgPad
* + pkg_bump_ns_ew_17_6_pkgPad
* + pkg_bump_ns_ew_17_7_pkgPad
* + pkg_bump_ns_ew_18_0_pkgPad
* + pkg_bump_ns_ew_18_1_pkgPad
* + pkg_bump_ns_ew_18_2_pkgPad
* + pkg_bump_ns_ew_18_3_pkgPad
* + pkg_bump_ns_ew_18_4_pkgPad
* + pkg_bump_ns_ew_18_5_pkgPad
* + pkg_bump_ns_ew_18_6_pkgPad
* + pkg_bump_ns_ew_18_7_pkgPad
* + pkg_bump_ns_ew_19_0_pkgPad
* + pkg_bump_ns_ew_19_1_pkgPad
* + pkg_bump_ns_ew_19_2_pkgPad
* + pkg_bump_ns_ew_19_3_pkgPad
* + pkg_bump_ns_ew_19_4_pkgPad
* + pkg_bump_ns_ew_19_5_pkgPad
* + pkg_bump_ns_ew_19_6_pkgPad
* + pkg_bump_ns_ew_19_7_pkgPad
* + pkg_bump_ns_ew_20_0_pkgPad
* + pkg_bump_ns_ew_20_1_pkgPad
* + pkg_bump_ns_ew_20_2_pkgPad
* + pkg_bump_ns_ew_20_3_pkgPad
* + pkg_bump_ns_ew_20_4_pkgPad
* + pkg_bump_ns_ew_20_5_pkgPad
* + pkg_bump_ns_ew_20_6_pkgPad
* + pkg_bump_ns_ew_20_7_pkgPad
* + pkg_bump_ns_ew_21_0_pkgPad
* + pkg_bump_ns_ew_21_1_pkgPad
* + pkg_bump_ns_ew_21_2_pkgPad
* + pkg_bump_ns_ew_21_3_pkgPad
* + pkg_bump_ns_ew_21_4_pkgPad
* + pkg_bump_ns_ew_21_5_pkgPad
* + pkg_bump_ns_ew_21_6_pkgPad
* + pkg_bump_ns_ew_21_7_pkgPad
* + pkg_bump_ns_ew_22_0_pkgPad
* + pkg_bump_ns_ew_22_1_pkgPad
* + pkg_bump_ns_ew_22_2_pkgPad
* + pkg_bump_ns_ew_22_3_pkgPad
* + pkg_bump_ns_ew_22_4_pkgPad
* + pkg_bump_ns_ew_22_5_pkgPad
* + pkg_bump_ns_ew_22_6_pkgPad
* + pkg_bump_ns_ew_22_7_pkgPad
* + pkg_bump_ns_ew_23_0_pkgPad
* + pkg_bump_ns_ew_23_1_pkgPad
* + pkg_bump_ns_ew_23_2_pkgPad
* + pkg_bump_ns_ew_23_3_pkgPad
* + pkg_bump_ns_ew_23_4_pkgPad
* + pkg_bump_ns_ew_23_5_pkgPad
* + pkg_bump_ns_ew_23_6_pkgPad
* + pkg_bump_ns_ew_23_7_pkgPad
* + bga_3_7
* + bga_2_7
* + bga_1_7
* + bga_0_7
* + bga_3_6
* + bga_2_6
* + bga_1_6
* + bga_0_6
* + bga_3_5
* + bga_2_5
* + bga_1_5
* + bga_0_5
* + bga_3_4
* + bga_2_4
* + bga_1_4
* + bga_0_4
* + bga_3_3
* + bga_2_3
* + bga_1_3
* + bga_0_3
* + bga_3_2
* + bga_2_2
* + bga_1_2
* + bga_0_2
* + bga_3_1
* + bga_2_1
* + bga_1_1
* + bga_0_1
* + bga_3_0
* + bga_2_0
* + bga_1_0
* + bga_0_0
* + bga_OUT_0_1
* + bga_OUT_0_2
* + bga_OUT_0_3
* + bga_OUT_0_4
* + bga_OUT_1_1
* + bga_OUT_1_2
* + bga_OUT_1_3
* + bga_OUT_1_4
* + pkge_Ecap1_1x1mm
* + pkge_Ecap2_1x1mm
* + pkge_Ecap3_1x1mm
* + pkge_Ecap4_1x1mm
* + pkge_Ecap5_1x1mm
* + pkge_Ecap6_1x1mm
* + pkge_Ecap7_1x1mm
* + pkge_Ecap8_1x1mm
* + pkge_Ecap9_1x1mm
* + pkge_Ecap10_1x1mm
* + pkge_Ecap11_1x1mm
* + pkge_Ecap12_1x1mm
* + ref_gnd
* + mam_mcm_l12_bh9_ballv1p00_260604_1_v7_12x1mm_Ecap_redu_modif_IdEM

				* .model pkg_spara_debug_model S
				* * * + TSTONEFILE = '/data/home/jiangongwei/work/port_reduction/NNE_pkg_251205_opt1C_4xEcap/NNE_only_MAM_ECAP_120624_1_1C_251205_2025R1.s240p'

				* * + TSTONEFILE = ' /data/home/jiangongwei/work/PDN_core/hspice_inc/NNE_pkg_B0_AndesSIW_jgweiGrping_260120.s240p'    *** Mam_MCM_L12_BH9_addecap85_solid_NNE_251225_Group_DSCs_jgwei.siw

				* * + TSTONEFILE = '/data/home/jiangongwei/work/port_reduction/NNE_pkg_260101_Andes/NNE_pkg_260101_Andes_2024_R2_HFSS_PI_modif.s240p'
				* + TSTONEFILE = '/data/home/jiangongwei/work/port_reduction/NNE_pkg_260101_Andes/NNE_pkg_260101_Andes_2025R1_discrete.s240p'

				* * + TSTONEFILE = '/data/home/jiangongwei/work/port_reduction/NNE_pkg_251205_opt1C_4xEcap/NNE_only_MAM_ECAP_120624_1_1C_251205_2025R1_redu_DSC_Opt1.s240p'
				* * + TSTONEFILE = '/data/home/jiangongwei/work/port_reduction/NNE_pkg_251205_opt1C_4xEcap/NNE_only_MAM_ECAP_120624_1_1C_251205_2025R1_redu_DSC_Opt2.s240p'
				* * + TSTONEFILE = '/data/home/jiangongwei/work/port_reduction/NNE_pkg_251205_opt1C_4xEcap/NNE_only_MAM_ECAP_120624_1_1C_251205_2025R1_redu_DSC_Opt3.s240p'
				* * + TSTONEFILE = '/data/home/jiangongwei/work/port_reduction/NNE_pkg_251205_opt1C_4xEcap/NNE_only_MAM_ECAP_120624_1_1C_251205_2025R1_redu_DSC_Opt4.s240p'
				* * + TSTONEFILE = '/data/home/jiangongwei/work/port_reduction/NNE_pkg_251205_opt1C_4xEcap/NNE_only_MAM_ECAP_120624_1_1C_251205_2025R1_redu_DSC_Opt5.s240p'
				* + FMAX= 1G

				* S_blk_pkg
                * + pkg_bump_ns_ew_0_0_pkgPad
                * + pkg_bump_ns_ew_0_1_pkgPad
                * + pkg_bump_ns_ew_0_2_pkgPad
                * + pkg_bump_ns_ew_0_3_pkgPad
                * + pkg_bump_ns_ew_0_4_pkgPad
                * + pkg_bump_ns_ew_0_5_pkgPad
                * + pkg_bump_ns_ew_0_6_pkgPad
                * + pkg_bump_ns_ew_0_7_pkgPad
                * + pkg_bump_ns_ew_1_0_pkgPad
                * + pkg_bump_ns_ew_1_1_pkgPad
                * + pkg_bump_ns_ew_1_2_pkgPad
                * + pkg_bump_ns_ew_1_3_pkgPad
                * + pkg_bump_ns_ew_1_4_pkgPad
                * + pkg_bump_ns_ew_1_5_pkgPad
                * + pkg_bump_ns_ew_1_6_pkgPad
                * + pkg_bump_ns_ew_1_7_pkgPad
                * + pkg_bump_ns_ew_2_0_pkgPad
                * + pkg_bump_ns_ew_2_1_pkgPad
                * + pkg_bump_ns_ew_2_2_pkgPad
                * + pkg_bump_ns_ew_2_3_pkgPad
                * + pkg_bump_ns_ew_2_4_pkgPad
                * + pkg_bump_ns_ew_2_5_pkgPad
                * + pkg_bump_ns_ew_2_6_pkgPad
                * + pkg_bump_ns_ew_2_7_pkgPad
                * + pkg_bump_ns_ew_3_0_pkgPad
                * + pkg_bump_ns_ew_3_1_pkgPad
                * + pkg_bump_ns_ew_3_2_pkgPad
                * + pkg_bump_ns_ew_3_3_pkgPad
                * + pkg_bump_ns_ew_3_4_pkgPad
                * + pkg_bump_ns_ew_3_5_pkgPad
                * + pkg_bump_ns_ew_3_6_pkgPad
                * + pkg_bump_ns_ew_3_7_pkgPad
                * + pkg_bump_ns_ew_4_0_pkgPad
                * + pkg_bump_ns_ew_4_1_pkgPad
                * + pkg_bump_ns_ew_4_2_pkgPad
                * + pkg_bump_ns_ew_4_3_pkgPad
                * + pkg_bump_ns_ew_4_4_pkgPad
                * + pkg_bump_ns_ew_4_5_pkgPad
                * + pkg_bump_ns_ew_4_6_pkgPad
                * + pkg_bump_ns_ew_4_7_pkgPad
                * + pkg_bump_ns_ew_5_0_pkgPad
                * + pkg_bump_ns_ew_5_1_pkgPad
                * + pkg_bump_ns_ew_5_2_pkgPad
                * + pkg_bump_ns_ew_5_3_pkgPad
                * + pkg_bump_ns_ew_5_4_pkgPad
                * + pkg_bump_ns_ew_5_5_pkgPad
                * + pkg_bump_ns_ew_5_6_pkgPad
                * + pkg_bump_ns_ew_5_7_pkgPad
                * + pkg_bump_ns_ew_6_0_pkgPad
                * + pkg_bump_ns_ew_6_1_pkgPad
                * + pkg_bump_ns_ew_6_2_pkgPad
                * + pkg_bump_ns_ew_6_3_pkgPad
                * + pkg_bump_ns_ew_6_4_pkgPad
                * + pkg_bump_ns_ew_6_5_pkgPad
                * + pkg_bump_ns_ew_6_6_pkgPad
                * + pkg_bump_ns_ew_6_7_pkgPad
                * + pkg_bump_ns_ew_7_0_pkgPad
                * + pkg_bump_ns_ew_7_1_pkgPad
                * + pkg_bump_ns_ew_7_2_pkgPad
                * + pkg_bump_ns_ew_7_3_pkgPad
                * + pkg_bump_ns_ew_7_4_pkgPad
                * + pkg_bump_ns_ew_7_5_pkgPad
                * + pkg_bump_ns_ew_7_6_pkgPad
                * + pkg_bump_ns_ew_7_7_pkgPad
                * + pkg_bump_ns_ew_8_0_pkgPad
                * + pkg_bump_ns_ew_8_1_pkgPad
                * + pkg_bump_ns_ew_8_2_pkgPad
                * + pkg_bump_ns_ew_8_3_pkgPad
                * + pkg_bump_ns_ew_8_4_pkgPad
                * + pkg_bump_ns_ew_8_5_pkgPad
                * + pkg_bump_ns_ew_8_6_pkgPad
                * + pkg_bump_ns_ew_8_7_pkgPad
                * + pkg_bump_ns_ew_9_0_pkgPad
                * + pkg_bump_ns_ew_9_1_pkgPad
                * + pkg_bump_ns_ew_9_2_pkgPad
                * + pkg_bump_ns_ew_9_3_pkgPad
                * + pkg_bump_ns_ew_9_4_pkgPad
                * + pkg_bump_ns_ew_9_5_pkgPad
                * + pkg_bump_ns_ew_9_6_pkgPad
                * + pkg_bump_ns_ew_9_7_pkgPad
                * + pkg_bump_ns_ew_10_0_pkgPad
                * + pkg_bump_ns_ew_10_1_pkgPad
                * + pkg_bump_ns_ew_10_2_pkgPad
                * + pkg_bump_ns_ew_10_3_pkgPad
                * + pkg_bump_ns_ew_10_4_pkgPad
                * + pkg_bump_ns_ew_10_5_pkgPad
                * + pkg_bump_ns_ew_10_6_pkgPad
                * + pkg_bump_ns_ew_10_7_pkgPad
                * + pkg_bump_ns_ew_11_0_pkgPad
                * + pkg_bump_ns_ew_11_1_pkgPad
                * + pkg_bump_ns_ew_11_2_pkgPad
                * + pkg_bump_ns_ew_11_3_pkgPad
                * + pkg_bump_ns_ew_11_4_pkgPad
                * + pkg_bump_ns_ew_11_5_pkgPad
                * + pkg_bump_ns_ew_11_6_pkgPad
                * + pkg_bump_ns_ew_11_7_pkgPad
                * + pkg_bump_ns_ew_12_0_pkgPad
                * + pkg_bump_ns_ew_12_1_pkgPad
                * + pkg_bump_ns_ew_12_2_pkgPad
                * + pkg_bump_ns_ew_12_3_pkgPad
                * + pkg_bump_ns_ew_12_4_pkgPad
                * + pkg_bump_ns_ew_12_5_pkgPad
                * + pkg_bump_ns_ew_12_6_pkgPad
                * + pkg_bump_ns_ew_12_7_pkgPad
                * + pkg_bump_ns_ew_13_0_pkgPad
                * + pkg_bump_ns_ew_13_1_pkgPad
                * + pkg_bump_ns_ew_13_2_pkgPad
                * + pkg_bump_ns_ew_13_3_pkgPad
                * + pkg_bump_ns_ew_13_4_pkgPad
                * + pkg_bump_ns_ew_13_5_pkgPad
                * + pkg_bump_ns_ew_13_6_pkgPad
                * + pkg_bump_ns_ew_13_7_pkgPad
                * + pkg_bump_ns_ew_14_0_pkgPad
                * + pkg_bump_ns_ew_14_1_pkgPad
                * + pkg_bump_ns_ew_14_2_pkgPad
                * + pkg_bump_ns_ew_14_3_pkgPad
                * + pkg_bump_ns_ew_14_4_pkgPad
                * + pkg_bump_ns_ew_14_5_pkgPad
                * + pkg_bump_ns_ew_14_6_pkgPad
                * + pkg_bump_ns_ew_14_7_pkgPad
                * + pkg_bump_ns_ew_15_0_pkgPad
                * + pkg_bump_ns_ew_15_1_pkgPad
                * + pkg_bump_ns_ew_15_2_pkgPad
                * + pkg_bump_ns_ew_15_3_pkgPad
                * + pkg_bump_ns_ew_15_4_pkgPad
                * + pkg_bump_ns_ew_15_5_pkgPad
                * + pkg_bump_ns_ew_15_6_pkgPad
                * + pkg_bump_ns_ew_15_7_pkgPad
                * + pkg_bump_ns_ew_16_0_pkgPad
                * + pkg_bump_ns_ew_16_1_pkgPad
                * + pkg_bump_ns_ew_16_2_pkgPad
                * + pkg_bump_ns_ew_16_3_pkgPad
                * + pkg_bump_ns_ew_16_4_pkgPad
                * + pkg_bump_ns_ew_16_5_pkgPad
                * + pkg_bump_ns_ew_16_6_pkgPad
                * + pkg_bump_ns_ew_16_7_pkgPad
                * + pkg_bump_ns_ew_17_0_pkgPad
                * + pkg_bump_ns_ew_17_1_pkgPad
                * + pkg_bump_ns_ew_17_2_pkgPad
                * + pkg_bump_ns_ew_17_3_pkgPad
                * + pkg_bump_ns_ew_17_4_pkgPad
                * + pkg_bump_ns_ew_17_5_pkgPad
                * + pkg_bump_ns_ew_17_6_pkgPad
                * + pkg_bump_ns_ew_17_7_pkgPad
                * + pkg_bump_ns_ew_18_0_pkgPad
                * + pkg_bump_ns_ew_18_1_pkgPad
                * + pkg_bump_ns_ew_18_2_pkgPad
                * + pkg_bump_ns_ew_18_3_pkgPad
                * + pkg_bump_ns_ew_18_4_pkgPad
                * + pkg_bump_ns_ew_18_5_pkgPad
                * + pkg_bump_ns_ew_18_6_pkgPad
                * + pkg_bump_ns_ew_18_7_pkgPad
                * + pkg_bump_ns_ew_19_0_pkgPad
                * + pkg_bump_ns_ew_19_1_pkgPad
                * + pkg_bump_ns_ew_19_2_pkgPad
                * + pkg_bump_ns_ew_19_3_pkgPad
                * + pkg_bump_ns_ew_19_4_pkgPad
                * + pkg_bump_ns_ew_19_5_pkgPad
                * + pkg_bump_ns_ew_19_6_pkgPad
                * + pkg_bump_ns_ew_19_7_pkgPad
                * + pkg_bump_ns_ew_20_0_pkgPad
                * + pkg_bump_ns_ew_20_1_pkgPad
                * + pkg_bump_ns_ew_20_2_pkgPad
                * + pkg_bump_ns_ew_20_3_pkgPad
                * + pkg_bump_ns_ew_20_4_pkgPad
                * + pkg_bump_ns_ew_20_5_pkgPad
                * + pkg_bump_ns_ew_20_6_pkgPad
                * + pkg_bump_ns_ew_20_7_pkgPad
                * + pkg_bump_ns_ew_21_0_pkgPad
                * + pkg_bump_ns_ew_21_1_pkgPad
                * + pkg_bump_ns_ew_21_2_pkgPad
                * + pkg_bump_ns_ew_21_3_pkgPad
                * + pkg_bump_ns_ew_21_4_pkgPad
                * + pkg_bump_ns_ew_21_5_pkgPad
                * + pkg_bump_ns_ew_21_6_pkgPad
                * + pkg_bump_ns_ew_21_7_pkgPad
                * + pkg_bump_ns_ew_22_0_pkgPad
                * + pkg_bump_ns_ew_22_1_pkgPad
                * + pkg_bump_ns_ew_22_2_pkgPad
                * + pkg_bump_ns_ew_22_3_pkgPad
                * + pkg_bump_ns_ew_22_4_pkgPad
                * + pkg_bump_ns_ew_22_5_pkgPad
                * + pkg_bump_ns_ew_22_6_pkgPad
                * + pkg_bump_ns_ew_22_7_pkgPad
                * + pkg_bump_ns_ew_23_0_pkgPad
                * + pkg_bump_ns_ew_23_1_pkgPad
                * + pkg_bump_ns_ew_23_2_pkgPad
                * + pkg_bump_ns_ew_23_3_pkgPad
                * + pkg_bump_ns_ew_23_4_pkgPad
                * + pkg_bump_ns_ew_23_5_pkgPad
                * + pkg_bump_ns_ew_23_6_pkgPad
                * + pkg_bump_ns_ew_23_7_pkgPad
                * + bga_3_7
                * + bga_2_7
                * + bga_1_7
                * + bga_0_7
                * + bga_3_6
                * + bga_2_6
                * + bga_1_6
                * + bga_0_6
                * + bga_3_5
                * + bga_2_5
                * + bga_1_5
                * + bga_0_5
                * + bga_3_4
                * + bga_2_4
                * + bga_1_4
                * + bga_0_4
                * + bga_3_3
                * + bga_2_3
                * + bga_1_3
                * + bga_0_3
                * + bga_3_2
                * + bga_2_2
                * + bga_1_2
                * + bga_0_2
                * + bga_3_1
                * + bga_2_1
                * + bga_1_1
                * + bga_0_1
                * + bga_3_0
                * + bga_2_0
                * + bga_1_0
                * + bga_0_0
                * + bga_OUT_0_1
                * + bga_OUT_0_2
                * + bga_OUT_0_3
                * + bga_OUT_0_4
                * + bga_OUT_1_1
                * + bga_OUT_1_2
                * + bga_OUT_1_3
                * + bga_OUT_1_4
                * + pkge_Ecap1_2x2mm_1
                * + pkge_Ecap1_2x2mm_2
                * + pkge_Ecap2_2x2mm_1
                * + pkge_Ecap2_2x2mm_2
                * + pkge_Ecap3_2x2mm_1
                * + pkge_Ecap3_2x2mm_2
                * + pkge_Ecap4_2x2mm_1
                * + pkge_Ecap4_2x2mm_2
			    * + mname = pkg_spara_debug_model

.if (is_use_ecap_ebed == 1)
	***  EC2005P w/ no. mounting R/L
	.if (ecap_choice == -1)	*** mock up ecaps connected to bump grps, mounting RL use default if R_mt and L_mt not set to 1.f
		xEcap_2005_inst1  pkg_bump_ns_ew_20_5 	pkg_bump_ns_ew_19_5 pkg_bump_ns_ew_18_5	pkg_bump_ns_ew_17_5 ref_gnd siCap_EC2005P_4Part_RL_LowESRL   R_mt=1.f	L_mt=1.f
		xEcap_2005_inst2  pkg_bump_ns_ew_11_5 	pkg_bump_ns_ew_10_5 pkg_bump_ns_ew_9_5	pkg_bump_ns_ew_8_5 ref_gnd 	siCap_EC2005P_4Part_RL_LowESRL   R_mt=1.f	L_mt=1.f
		xEcap_2005_inst3  pkg_bump_ns_ew_15_2 	pkg_bump_ns_ew_14_2 pkg_bump_ns_ew_13_2	pkg_bump_ns_ew_12_2 ref_gnd siCap_EC2005P_4Part_RL_LowESRL   R_mt=1.f	L_mt=1.f
		xEcap_2005_inst4  pkg_bump_ns_ew_6_2 	pkg_bump_ns_ew_5_2 	pkg_bump_ns_ew_4_2	pkg_bump_ns_ew_3_2 ref_gnd 	siCap_EC2005P_4Part_RL_LowESRL	 R_mt=1.f	L_mt=1.f
	.endif

	.if (ecap_choice == 0)	*** real ecap pad connection, mounting R/L should be 0
		xEcap_2005_inst1	pkge_Ecap1_2x2mm_1 pkge_Ecap1_2x2mm_2  ref_gnd	siCap_EC2005P  R_mt=1.f	L_mt=1.f 		*** disable this if pkg model used as opt.1B, since in opt.2B pkg ports, this is the Ecap outside NNE die shadow
		xEcap_2005_inst2	pkge_Ecap2_2x2mm_1 pkge_Ecap2_2x2mm_2  ref_gnd	siCap_EC2005P  R_mt=1.f	L_mt=1.f
		xEcap_2005_inst3	pkge_Ecap3_2x2mm_1 pkge_Ecap3_2x2mm_2  ref_gnd	siCap_EC2005P  R_mt=1.f	L_mt=1.f
		xEcap_2005_inst4	pkge_Ecap4_2x2mm_1 pkge_Ecap4_2x2mm_2  ref_gnd	siCap_EC2005P  R_mt=1.f	L_mt=1.f
		* xEcap_2005_inst5	pkge_Ecap5_2x2mm_1 pkge_Ecap5_2x2mm_2  ref_gnd	siCap_EC2005P  R_mt=1.f	L_mt=1.f

		*** this is for 1x1mm
		xEcap_2005_qt_inst1		pkge_Ecap1_1x1mm ref_gnd	siCap_EC2005P_qt  R_mt=1.f	L_mt=1.f
		xEcap_2005_qt_inst2		pkge_Ecap2_1x1mm ref_gnd	siCap_EC2005P_qt  R_mt=1.f	L_mt=1.f
		xEcap_2005_qt_inst3		pkge_Ecap3_1x1mm ref_gnd	siCap_EC2005P_qt  R_mt=1.f	L_mt=1.f
		xEcap_2005_qt_inst4		pkge_Ecap4_1x1mm ref_gnd	siCap_EC2005P_qt  R_mt=1.f	L_mt=1.f
		xEcap_2005_qt_inst5		pkge_Ecap5_1x1mm ref_gnd	siCap_EC2005P_qt  R_mt=1.f	L_mt=1.f
		xEcap_2005_qt_inst6		pkge_Ecap6_1x1mm ref_gnd	siCap_EC2005P_qt  R_mt=1.f	L_mt=1.f
		xEcap_2005_qt_inst7		pkge_Ecap7_1x1mm ref_gnd	siCap_EC2005P_qt  R_mt=1.f	L_mt=1.f
		xEcap_2005_qt_inst8		pkge_Ecap8_1x1mm ref_gnd	siCap_EC2005P_qt  R_mt=1.f	L_mt=1.f
		xEcap_2005_qt_inst9		pkge_Ecap9_1x1mm ref_gnd	siCap_EC2005P_qt  R_mt=1.f	L_mt=1.f
		xEcap_2005_qt_inst10	pkge_Ecap10_1x1mm ref_gnd	siCap_EC2005P_qt  R_mt=1.f	L_mt=1.f
		xEcap_2005_qt_inst11	pkge_Ecap11_1x1mm ref_gnd	siCap_EC2005P_qt  R_mt=1.f	L_mt=1.f
		xEcap_2005_qt_inst12	pkge_Ecap12_1x1mm ref_gnd	siCap_EC2005P_qt  R_mt=1.f	L_mt=1.f

	.endif

	.if (ecap_choice == 1)	*** real ecap pad connection, mounting R/L should be 0
		xEcap_2005_inst1	pkge_Ecap1_2x2mm_1 ref_gnd	SCRLLC106MG6EGNNWT_Simple_DC0V_25degC_PC_V01  R_mt=1.f	L_mt=1.f 		*** disable this if pkg model used as opt.1B, since in opt.2B pkg ports, this is the Ecap outside NNE die shadow
		xEcap_2005_inst2	pkge_Ecap2_2x2mm_1 ref_gnd	SCRLLC106MG6EGNNWT_Simple_DC0V_25degC_PC_V01  R_mt=1.f	L_mt=1.f
		xEcap_2005_inst3	pkge_Ecap3_2x2mm_1 ref_gnd	SCRLLC106MG6EGNNWT_Simple_DC0V_25degC_PC_V01  R_mt=1.f	L_mt=1.f
		xEcap_2005_inst4	pkge_Ecap4_2x2mm_1 ref_gnd	SCRLLC106MG6EGNNWT_Simple_DC0V_25degC_PC_V01  R_mt=1.f	L_mt=1.f
		* xEcap_2005_inst5	pkge_Ecap5_2x2mm_1 ref_gnd	SCRLLC106MG6EGNNWT_Simple_DC0V_25degC_PC_V01  R_mt=1.f	L_mt=1.f

		r_short_ecap1 pkge_Ecap1_2x2mm_1	pkge_Ecap1_2x2mm_2	1.f
		r_short_ecap2 pkge_Ecap2_2x2mm_1	pkge_Ecap2_2x2mm_2	1.f
		r_short_ecap3 pkge_Ecap3_2x2mm_1	pkge_Ecap3_2x2mm_2	1.f
		r_short_ecap4 pkge_Ecap4_2x2mm_1	pkge_Ecap4_2x2mm_2	1.f
		* r_short_ecap5 pkge_Ecap5_2x2mm_1	pkge_Ecap5_2x2mm_2	1.f

	.endif

	.if (ecap_choice == 2)	*** real ecap pad connection, mounting R/L should be 0
		xEcap_2005_inst1	pkge_Ecap1_2x2mm_1 ref_gnd	SCRLLC885MG6EGNNWT_Simple_DC0V_25degC_PC_V01  R_mt=1.f	L_mt=1.f 		*** disable this if pkg model used as opt.1B, since in opt.2B pkg ports, this is the Ecap outside NNE die shadow
		xEcap_2005_inst2	pkge_Ecap2_2x2mm_1 ref_gnd	SCRLLC885MG6EGNNWT_Simple_DC0V_25degC_PC_V01  R_mt=1.f	L_mt=1.f
		xEcap_2005_inst3	pkge_Ecap3_2x2mm_1 ref_gnd	SCRLLC885MG6EGNNWT_Simple_DC0V_25degC_PC_V01  R_mt=1.f	L_mt=1.f
		xEcap_2005_inst4	pkge_Ecap4_2x2mm_1 ref_gnd	SCRLLC885MG6EGNNWT_Simple_DC0V_25degC_PC_V01  R_mt=1.f	L_mt=1.f
		xEcap_2005_inst5	pkge_Ecap5_2x2mm_1 ref_gnd	SCRLLC885MG6EGNNWT_Simple_DC0V_25degC_PC_V01  R_mt=1.f	L_mt=1.f

		r_short_ecap1 pkge_Ecap1_2x2mm_1	pkge_Ecap1_2x2mm_2	1.f
		r_short_ecap2 pkge_Ecap2_2x2mm_1	pkge_Ecap2_2x2mm_2	1.f
		r_short_ecap3 pkge_Ecap3_2x2mm_1	pkge_Ecap3_2x2mm_2	1.f
		r_short_ecap4 pkge_Ecap4_2x2mm_1	pkge_Ecap4_2x2mm_2	1.f
		r_short_ecap5 pkge_Ecap5_2x2mm_1	pkge_Ecap5_2x2mm_2	1.f

	.endif

.endif

*************************************** Die ***********************************
.if (is_use_MIM != 1)
		* r_short_pa3_ma3  pkg_bump_PA_ns_3	pkg_bump_MA_ns_3	1.n
		* xblk_die pkg_bump_PA_ns_3 ref_gnd	model_die_lumped_nne_tile C_die= 327.5n  R_die_1= 0.072m R_die_2= 1.n  R_leak = 1.	pwlfile = str(pwl_file_in_PAMA)		*** debug to use one parition

	xblk_die					*** POR
	+ pkg_bump_ns_ew_0_0
	+ pkg_bump_ns_ew_1_0
	+ pkg_bump_ns_ew_2_0
	+ pkg_bump_ns_ew_3_0
	+ pkg_bump_ns_ew_4_0
	+ pkg_bump_ns_ew_5_0
	+ pkg_bump_ns_ew_6_0
	+ pkg_bump_ns_ew_7_0
	+ pkg_bump_ns_ew_8_0
	+ pkg_bump_ns_ew_9_0
	+ pkg_bump_ns_ew_10_0
	+ pkg_bump_ns_ew_11_0
	+ pkg_bump_ns_ew_12_0
	+ pkg_bump_ns_ew_13_0
	+ pkg_bump_ns_ew_14_0
	+ pkg_bump_ns_ew_15_0
	+ pkg_bump_ns_ew_16_0
	+ pkg_bump_ns_ew_17_0
	+ pkg_bump_ns_ew_18_0
	+ pkg_bump_ns_ew_19_0
	+ pkg_bump_ns_ew_20_0
	+ pkg_bump_ns_ew_21_0
	+ pkg_bump_ns_ew_22_0
	+ pkg_bump_ns_ew_23_0
	+ pkg_bump_ns_ew_0_1
	+ pkg_bump_ns_ew_1_1
	+ pkg_bump_ns_ew_2_1
	+ pkg_bump_ns_ew_3_1
	+ pkg_bump_ns_ew_4_1
	+ pkg_bump_ns_ew_5_1
	+ pkg_bump_ns_ew_6_1
	+ pkg_bump_ns_ew_7_1
	+ pkg_bump_ns_ew_8_1
	+ pkg_bump_ns_ew_9_1
	+ pkg_bump_ns_ew_10_1
	+ pkg_bump_ns_ew_11_1
	+ pkg_bump_ns_ew_12_1
	+ pkg_bump_ns_ew_13_1
	+ pkg_bump_ns_ew_14_1
	+ pkg_bump_ns_ew_15_1
	+ pkg_bump_ns_ew_16_1
	+ pkg_bump_ns_ew_17_1
	+ pkg_bump_ns_ew_18_1
	+ pkg_bump_ns_ew_19_1
	+ pkg_bump_ns_ew_20_1
	+ pkg_bump_ns_ew_21_1
	+ pkg_bump_ns_ew_22_1
	+ pkg_bump_ns_ew_23_1
	+ pkg_bump_ns_ew_0_2
	+ pkg_bump_ns_ew_1_2
	+ pkg_bump_ns_ew_2_2
	+ pkg_bump_ns_ew_3_2
	+ pkg_bump_ns_ew_4_2
	+ pkg_bump_ns_ew_5_2
	+ pkg_bump_ns_ew_6_2
	+ pkg_bump_ns_ew_7_2
	+ pkg_bump_ns_ew_8_2
	+ pkg_bump_ns_ew_9_2
	+ pkg_bump_ns_ew_10_2
	+ pkg_bump_ns_ew_11_2
	+ pkg_bump_ns_ew_12_2
	+ pkg_bump_ns_ew_13_2
	+ pkg_bump_ns_ew_14_2
	+ pkg_bump_ns_ew_15_2
	+ pkg_bump_ns_ew_16_2
	+ pkg_bump_ns_ew_17_2
	+ pkg_bump_ns_ew_18_2
	+ pkg_bump_ns_ew_19_2
	+ pkg_bump_ns_ew_20_2
	+ pkg_bump_ns_ew_21_2
	+ pkg_bump_ns_ew_22_2
	+ pkg_bump_ns_ew_23_2
	+ pkg_bump_ns_ew_0_3
	+ pkg_bump_ns_ew_1_3
	+ pkg_bump_ns_ew_2_3
	+ pkg_bump_ns_ew_3_3
	+ pkg_bump_ns_ew_4_3
	+ pkg_bump_ns_ew_5_3
	+ pkg_bump_ns_ew_6_3
	+ pkg_bump_ns_ew_7_3
	+ pkg_bump_ns_ew_8_3
	+ pkg_bump_ns_ew_9_3
	+ pkg_bump_ns_ew_10_3
	+ pkg_bump_ns_ew_11_3
	+ pkg_bump_ns_ew_12_3
	+ pkg_bump_ns_ew_13_3
	+ pkg_bump_ns_ew_14_3
	+ pkg_bump_ns_ew_15_3
	+ pkg_bump_ns_ew_16_3
	+ pkg_bump_ns_ew_17_3
	+ pkg_bump_ns_ew_18_3
	+ pkg_bump_ns_ew_19_3
	+ pkg_bump_ns_ew_20_3
	+ pkg_bump_ns_ew_21_3
	+ pkg_bump_ns_ew_22_3
	+ pkg_bump_ns_ew_23_3
	+ pkg_bump_ns_ew_0_4
	+ pkg_bump_ns_ew_1_4
	+ pkg_bump_ns_ew_2_4
	+ pkg_bump_ns_ew_3_4
	+ pkg_bump_ns_ew_4_4
	+ pkg_bump_ns_ew_5_4
	+ pkg_bump_ns_ew_6_4
	+ pkg_bump_ns_ew_7_4
	+ pkg_bump_ns_ew_8_4
	+ pkg_bump_ns_ew_9_4
	+ pkg_bump_ns_ew_10_4
	+ pkg_bump_ns_ew_11_4
	+ pkg_bump_ns_ew_12_4
	+ pkg_bump_ns_ew_13_4
	+ pkg_bump_ns_ew_14_4
	+ pkg_bump_ns_ew_15_4
	+ pkg_bump_ns_ew_16_4
	+ pkg_bump_ns_ew_17_4
	+ pkg_bump_ns_ew_18_4
	+ pkg_bump_ns_ew_19_4
	+ pkg_bump_ns_ew_20_4
	+ pkg_bump_ns_ew_21_4
	+ pkg_bump_ns_ew_22_4
	+ pkg_bump_ns_ew_23_4
	+ pkg_bump_ns_ew_0_5
	+ pkg_bump_ns_ew_1_5
	+ pkg_bump_ns_ew_2_5
	+ pkg_bump_ns_ew_3_5
	+ pkg_bump_ns_ew_4_5
	+ pkg_bump_ns_ew_5_5
	+ pkg_bump_ns_ew_6_5
	+ pkg_bump_ns_ew_7_5
	+ pkg_bump_ns_ew_8_5
	+ pkg_bump_ns_ew_9_5
	+ pkg_bump_ns_ew_10_5
	+ pkg_bump_ns_ew_11_5
	+ pkg_bump_ns_ew_12_5
	+ pkg_bump_ns_ew_13_5
	+ pkg_bump_ns_ew_14_5
	+ pkg_bump_ns_ew_15_5
	+ pkg_bump_ns_ew_16_5
	+ pkg_bump_ns_ew_17_5
	+ pkg_bump_ns_ew_18_5
	+ pkg_bump_ns_ew_19_5
	+ pkg_bump_ns_ew_20_5
	+ pkg_bump_ns_ew_21_5
	+ pkg_bump_ns_ew_22_5
	+ pkg_bump_ns_ew_23_5
	+ pkg_bump_ns_ew_0_6
	+ pkg_bump_ns_ew_1_6
	+ pkg_bump_ns_ew_2_6
	+ pkg_bump_ns_ew_3_6
	+ pkg_bump_ns_ew_4_6
	+ pkg_bump_ns_ew_5_6
	+ pkg_bump_ns_ew_6_6
	+ pkg_bump_ns_ew_7_6
	+ pkg_bump_ns_ew_8_6
	+ pkg_bump_ns_ew_9_6
	+ pkg_bump_ns_ew_10_6
	+ pkg_bump_ns_ew_11_6
	+ pkg_bump_ns_ew_12_6
	+ pkg_bump_ns_ew_13_6
	+ pkg_bump_ns_ew_14_6
	+ pkg_bump_ns_ew_15_6
	+ pkg_bump_ns_ew_16_6
	+ pkg_bump_ns_ew_17_6
	+ pkg_bump_ns_ew_18_6
	+ pkg_bump_ns_ew_19_6
	+ pkg_bump_ns_ew_20_6
	+ pkg_bump_ns_ew_21_6
	+ pkg_bump_ns_ew_22_6
	+ pkg_bump_ns_ew_23_6
	+ pkg_bump_ns_ew_0_7
	+ pkg_bump_ns_ew_1_7
	+ pkg_bump_ns_ew_2_7
	+ pkg_bump_ns_ew_3_7
	+ pkg_bump_ns_ew_4_7
	+ pkg_bump_ns_ew_5_7
	+ pkg_bump_ns_ew_6_7
	+ pkg_bump_ns_ew_7_7
	+ pkg_bump_ns_ew_8_7
	+ pkg_bump_ns_ew_9_7
	+ pkg_bump_ns_ew_10_7
	+ pkg_bump_ns_ew_11_7
	+ pkg_bump_ns_ew_12_7
	+ pkg_bump_ns_ew_13_7
	+ pkg_bump_ns_ew_14_7
	+ pkg_bump_ns_ew_15_7
	+ pkg_bump_ns_ew_16_7
	+ pkg_bump_ns_ew_17_7
	+ pkg_bump_ns_ew_18_7
	+ pkg_bump_ns_ew_19_7
	+ pkg_bump_ns_ew_20_7
	+ pkg_bump_ns_ew_21_7
	+ pkg_bump_ns_ew_22_7
	+ pkg_bump_ns_ew_23_7
	+ ref_gnd
	+ cpm_nne_24x8_MOR_251120_v3_IdEM_1e_3
	* + cpm_nne_24x8_MOR_Cx0p5_260302_IdEM_1e_4		*** debug use 0.5x C

	* xblk_die 	*** 24x8 NNE CPM w/o MIM, very SLOOOOOW
	* + 	      pkg_bump_ns_ew_0_0
	* + ref_gnd   pkg_bump_ns_ew_1_0
	* + ref_gnd   pkg_bump_ns_ew_2_0
	* + ref_gnd   pkg_bump_ns_ew_3_0
	* + ref_gnd   pkg_bump_ns_ew_4_0
	* + ref_gnd   pkg_bump_ns_ew_5_0
	* + ref_gnd   pkg_bump_ns_ew_6_0
	* + ref_gnd   pkg_bump_ns_ew_7_0
	* + ref_gnd   pkg_bump_ns_ew_8_0
	* + ref_gnd   pkg_bump_ns_ew_9_0
	* + ref_gnd   pkg_bump_ns_ew_10_0
	* + ref_gnd   pkg_bump_ns_ew_11_0
	* + ref_gnd   pkg_bump_ns_ew_12_0
	* + ref_gnd   pkg_bump_ns_ew_13_0
	* + ref_gnd   pkg_bump_ns_ew_14_0
	* + ref_gnd   pkg_bump_ns_ew_15_0
	* + ref_gnd   pkg_bump_ns_ew_16_0
	* + ref_gnd   pkg_bump_ns_ew_17_0
	* + ref_gnd   pkg_bump_ns_ew_18_0
	* + ref_gnd   pkg_bump_ns_ew_19_0
	* + ref_gnd   pkg_bump_ns_ew_20_0
	* + ref_gnd   pkg_bump_ns_ew_21_0
	* + ref_gnd   pkg_bump_ns_ew_22_0
	* + ref_gnd   pkg_bump_ns_ew_23_0
	* + ref_gnd   pkg_bump_ns_ew_0_1
	* + ref_gnd   pkg_bump_ns_ew_1_1
	* + ref_gnd   pkg_bump_ns_ew_2_1
	* + ref_gnd   pkg_bump_ns_ew_3_1
	* + ref_gnd   pkg_bump_ns_ew_4_1
	* + ref_gnd   pkg_bump_ns_ew_5_1
	* + ref_gnd   pkg_bump_ns_ew_6_1
	* + ref_gnd   pkg_bump_ns_ew_7_1
	* + ref_gnd   pkg_bump_ns_ew_8_1
	* + ref_gnd   pkg_bump_ns_ew_9_1
	* + ref_gnd   pkg_bump_ns_ew_10_1
	* + ref_gnd   pkg_bump_ns_ew_11_1
	* + ref_gnd   pkg_bump_ns_ew_12_1
	* + ref_gnd   pkg_bump_ns_ew_13_1
	* + ref_gnd   pkg_bump_ns_ew_14_1
	* + ref_gnd   pkg_bump_ns_ew_15_1
	* + ref_gnd   pkg_bump_ns_ew_16_1
	* + ref_gnd   pkg_bump_ns_ew_17_1
	* + ref_gnd   pkg_bump_ns_ew_18_1
	* + ref_gnd   pkg_bump_ns_ew_19_1
	* + ref_gnd   pkg_bump_ns_ew_20_1
	* + ref_gnd   pkg_bump_ns_ew_21_1
	* + ref_gnd   pkg_bump_ns_ew_22_1
	* + ref_gnd   pkg_bump_ns_ew_23_1
	* + ref_gnd   pkg_bump_ns_ew_0_2
	* + ref_gnd   pkg_bump_ns_ew_1_2
	* + ref_gnd   pkg_bump_ns_ew_2_2
	* + ref_gnd   pkg_bump_ns_ew_3_2
	* + ref_gnd   pkg_bump_ns_ew_4_2
	* + ref_gnd   pkg_bump_ns_ew_5_2
	* + ref_gnd   pkg_bump_ns_ew_6_2
	* + ref_gnd   pkg_bump_ns_ew_7_2
	* + ref_gnd   pkg_bump_ns_ew_8_2
	* + ref_gnd   pkg_bump_ns_ew_9_2
	* + ref_gnd   pkg_bump_ns_ew_10_2
	* + ref_gnd   pkg_bump_ns_ew_11_2
	* + ref_gnd   pkg_bump_ns_ew_12_2
	* + ref_gnd   pkg_bump_ns_ew_13_2
	* + ref_gnd   pkg_bump_ns_ew_14_2
	* + ref_gnd   pkg_bump_ns_ew_15_2
	* + ref_gnd   pkg_bump_ns_ew_16_2
	* + ref_gnd   pkg_bump_ns_ew_17_2
	* + ref_gnd   pkg_bump_ns_ew_18_2
	* + ref_gnd   pkg_bump_ns_ew_19_2
	* + ref_gnd   pkg_bump_ns_ew_20_2
	* + ref_gnd   pkg_bump_ns_ew_21_2
	* + ref_gnd   pkg_bump_ns_ew_22_2
	* + ref_gnd   pkg_bump_ns_ew_23_2
	* + ref_gnd   pkg_bump_ns_ew_0_3
	* + ref_gnd   pkg_bump_ns_ew_1_3
	* + ref_gnd   pkg_bump_ns_ew_2_3
	* + ref_gnd   pkg_bump_ns_ew_3_3
	* + ref_gnd   pkg_bump_ns_ew_4_3
	* + ref_gnd   pkg_bump_ns_ew_5_3
	* + ref_gnd   pkg_bump_ns_ew_6_3
	* + ref_gnd   pkg_bump_ns_ew_7_3
	* + ref_gnd   pkg_bump_ns_ew_8_3
	* + ref_gnd   pkg_bump_ns_ew_9_3
	* + ref_gnd   pkg_bump_ns_ew_10_3
	* + ref_gnd   pkg_bump_ns_ew_11_3
	* + ref_gnd   pkg_bump_ns_ew_12_3
	* + ref_gnd   pkg_bump_ns_ew_13_3
	* + ref_gnd   pkg_bump_ns_ew_14_3
	* + ref_gnd   pkg_bump_ns_ew_15_3
	* + ref_gnd   pkg_bump_ns_ew_16_3
	* + ref_gnd   pkg_bump_ns_ew_17_3
	* + ref_gnd   pkg_bump_ns_ew_18_3
	* + ref_gnd   pkg_bump_ns_ew_19_3
	* + ref_gnd   pkg_bump_ns_ew_20_3
	* + ref_gnd   pkg_bump_ns_ew_21_3
	* + ref_gnd   pkg_bump_ns_ew_22_3
	* + ref_gnd   pkg_bump_ns_ew_23_3
	* + ref_gnd   pkg_bump_ns_ew_0_4
	* + ref_gnd   pkg_bump_ns_ew_1_4
	* + ref_gnd   pkg_bump_ns_ew_2_4
	* + ref_gnd   pkg_bump_ns_ew_3_4
	* + ref_gnd   pkg_bump_ns_ew_4_4
	* + ref_gnd   pkg_bump_ns_ew_5_4
	* + ref_gnd   pkg_bump_ns_ew_6_4
	* + ref_gnd   pkg_bump_ns_ew_7_4
	* + ref_gnd   pkg_bump_ns_ew_8_4
	* + ref_gnd   pkg_bump_ns_ew_9_4
	* + ref_gnd   pkg_bump_ns_ew_10_4
	* + ref_gnd   pkg_bump_ns_ew_11_4
	* + ref_gnd   pkg_bump_ns_ew_12_4
	* + ref_gnd   pkg_bump_ns_ew_13_4
	* + ref_gnd   pkg_bump_ns_ew_14_4
	* + ref_gnd   pkg_bump_ns_ew_15_4
	* + ref_gnd   pkg_bump_ns_ew_16_4
	* + ref_gnd   pkg_bump_ns_ew_17_4
	* + ref_gnd   pkg_bump_ns_ew_18_4
	* + ref_gnd   pkg_bump_ns_ew_19_4
	* + ref_gnd   pkg_bump_ns_ew_20_4
	* + ref_gnd   pkg_bump_ns_ew_21_4
	* + ref_gnd   pkg_bump_ns_ew_22_4
	* + ref_gnd   pkg_bump_ns_ew_23_4
	* + ref_gnd   pkg_bump_ns_ew_0_5
	* + ref_gnd   pkg_bump_ns_ew_1_5
	* + ref_gnd   pkg_bump_ns_ew_2_5
	* + ref_gnd   pkg_bump_ns_ew_3_5
	* + ref_gnd   pkg_bump_ns_ew_4_5
	* + ref_gnd   pkg_bump_ns_ew_5_5
	* + ref_gnd   pkg_bump_ns_ew_6_5
	* + ref_gnd   pkg_bump_ns_ew_7_5
	* + ref_gnd   pkg_bump_ns_ew_8_5
	* + ref_gnd   pkg_bump_ns_ew_9_5
	* + ref_gnd   pkg_bump_ns_ew_10_5
	* + ref_gnd   pkg_bump_ns_ew_11_5
	* + ref_gnd   pkg_bump_ns_ew_12_5
	* + ref_gnd   pkg_bump_ns_ew_13_5
	* + ref_gnd   pkg_bump_ns_ew_14_5
	* + ref_gnd   pkg_bump_ns_ew_15_5
	* + ref_gnd   pkg_bump_ns_ew_16_5
	* + ref_gnd   pkg_bump_ns_ew_17_5
	* + ref_gnd   pkg_bump_ns_ew_18_5
	* + ref_gnd   pkg_bump_ns_ew_19_5
	* + ref_gnd   pkg_bump_ns_ew_20_5
	* + ref_gnd   pkg_bump_ns_ew_21_5
	* + ref_gnd   pkg_bump_ns_ew_22_5
	* + ref_gnd   pkg_bump_ns_ew_23_5
	* + ref_gnd   pkg_bump_ns_ew_0_6
	* + ref_gnd   pkg_bump_ns_ew_1_6
	* + ref_gnd   pkg_bump_ns_ew_2_6
	* + ref_gnd   pkg_bump_ns_ew_3_6
	* + ref_gnd   pkg_bump_ns_ew_4_6
	* + ref_gnd   pkg_bump_ns_ew_5_6
	* + ref_gnd   pkg_bump_ns_ew_6_6
	* + ref_gnd   pkg_bump_ns_ew_7_6
	* + ref_gnd   pkg_bump_ns_ew_8_6
	* + ref_gnd   pkg_bump_ns_ew_9_6
	* + ref_gnd   pkg_bump_ns_ew_10_6
	* + ref_gnd   pkg_bump_ns_ew_11_6
	* + ref_gnd   pkg_bump_ns_ew_12_6
	* + ref_gnd   pkg_bump_ns_ew_13_6
	* + ref_gnd   pkg_bump_ns_ew_14_6
	* + ref_gnd   pkg_bump_ns_ew_15_6
	* + ref_gnd   pkg_bump_ns_ew_16_6
	* + ref_gnd   pkg_bump_ns_ew_17_6
	* + ref_gnd   pkg_bump_ns_ew_18_6
	* + ref_gnd   pkg_bump_ns_ew_19_6
	* + ref_gnd   pkg_bump_ns_ew_20_6
	* + ref_gnd   pkg_bump_ns_ew_21_6
	* + ref_gnd   pkg_bump_ns_ew_22_6
	* + ref_gnd   pkg_bump_ns_ew_23_6
	* + ref_gnd   pkg_bump_ns_ew_0_7
	* + ref_gnd   pkg_bump_ns_ew_1_7
	* + ref_gnd   pkg_bump_ns_ew_2_7
	* + ref_gnd   pkg_bump_ns_ew_3_7
	* + ref_gnd   pkg_bump_ns_ew_4_7
	* + ref_gnd   pkg_bump_ns_ew_5_7
	* + ref_gnd   pkg_bump_ns_ew_6_7
	* + ref_gnd   pkg_bump_ns_ew_7_7
	* + ref_gnd   pkg_bump_ns_ew_8_7
	* + ref_gnd   pkg_bump_ns_ew_9_7
	* + ref_gnd   pkg_bump_ns_ew_10_7
	* + ref_gnd   pkg_bump_ns_ew_11_7
	* + ref_gnd   pkg_bump_ns_ew_12_7
	* + ref_gnd   pkg_bump_ns_ew_13_7
	* + ref_gnd   pkg_bump_ns_ew_14_7
	* + ref_gnd   pkg_bump_ns_ew_15_7
	* + ref_gnd   pkg_bump_ns_ew_16_7
	* + ref_gnd   pkg_bump_ns_ew_17_7
	* + ref_gnd   pkg_bump_ns_ew_18_7
	* + ref_gnd   pkg_bump_ns_ew_19_7
	* + ref_gnd   pkg_bump_ns_ew_20_7
	* + ref_gnd   pkg_bump_ns_ew_21_7
	* + ref_gnd   pkg_bump_ns_ew_22_7
	* + ref_gnd   pkg_bump_ns_ew_23_7
	* + ref_gnd
	* + CPM_adsPowerModel_NNE_24x8_251117
	* * + CPM_adsPowerModel_NNE_24x8_251117_Cx0p5	*** capacitance x 0.5 for debugging

*** experiment to check isolated cdie rdie model
* .subckt die_model_isolate
* + bump_pwr  bump_gnd
* c_mod bump_pwr  node0  		8.3n
* r_mod node0     bump_gnd	7.7m
* .ends die_model_isolate

* xblk_die_pkg_bump_ns_ew_0_0      pkg_bump_ns_ew_0_0 	ref_gnd die_model_isolate
* xblk_die_pkg_bump_ns_ew_0_1      pkg_bump_ns_ew_0_1     ref_gnd die_model_isolate
* xblk_die_pkg_bump_ns_ew_0_2      pkg_bump_ns_ew_0_2     ref_gnd die_model_isolate
* xblk_die_pkg_bump_ns_ew_0_3      pkg_bump_ns_ew_0_3     ref_gnd die_model_isolate
* xblk_die_pkg_bump_ns_ew_0_4      pkg_bump_ns_ew_0_4     ref_gnd die_model_isolate
* xblk_die_pkg_bump_ns_ew_0_5      pkg_bump_ns_ew_0_5     ref_gnd die_model_isolate
* xblk_die_pkg_bump_ns_ew_0_6      pkg_bump_ns_ew_0_6     ref_gnd die_model_isolate
* xblk_die_pkg_bump_ns_ew_0_7      pkg_bump_ns_ew_0_7     ref_gnd die_model_isolate
* xblk_die_pkg_bump_ns_ew_1_0      pkg_bump_ns_ew_1_0     ref_gnd die_model_isolate
* xblk_die_pkg_bump_ns_ew_1_1      pkg_bump_ns_ew_1_1     ref_gnd die_model_isolate
* xblk_die_pkg_bump_ns_ew_1_2      pkg_bump_ns_ew_1_2     ref_gnd die_model_isolate
* xblk_die_pkg_bump_ns_ew_1_3      pkg_bump_ns_ew_1_3     ref_gnd die_model_isolate
* xblk_die_pkg_bump_ns_ew_1_4      pkg_bump_ns_ew_1_4     ref_gnd die_model_isolate
* xblk_die_pkg_bump_ns_ew_1_5      pkg_bump_ns_ew_1_5     ref_gnd die_model_isolate
* xblk_die_pkg_bump_ns_ew_1_6      pkg_bump_ns_ew_1_6     ref_gnd die_model_isolate
* xblk_die_pkg_bump_ns_ew_1_7      pkg_bump_ns_ew_1_7     ref_gnd die_model_isolate
* xblk_die_pkg_bump_ns_ew_2_0      pkg_bump_ns_ew_2_0     ref_gnd die_model_isolate
* xblk_die_pkg_bump_ns_ew_2_1      pkg_bump_ns_ew_2_1     ref_gnd die_model_isolate
* xblk_die_pkg_bump_ns_ew_2_2      pkg_bump_ns_ew_2_2     ref_gnd die_model_isolate
* xblk_die_pkg_bump_ns_ew_2_3      pkg_bump_ns_ew_2_3     ref_gnd die_model_isolate
* xblk_die_pkg_bump_ns_ew_2_4      pkg_bump_ns_ew_2_4     ref_gnd die_model_isolate
* xblk_die_pkg_bump_ns_ew_2_5      pkg_bump_ns_ew_2_5     ref_gnd die_model_isolate
* xblk_die_pkg_bump_ns_ew_2_6      pkg_bump_ns_ew_2_6     ref_gnd die_model_isolate
* xblk_die_pkg_bump_ns_ew_2_7      pkg_bump_ns_ew_2_7     ref_gnd die_model_isolate
* xblk_die_pkg_bump_ns_ew_3_0      pkg_bump_ns_ew_3_0     ref_gnd die_model_isolate
* xblk_die_pkg_bump_ns_ew_3_1      pkg_bump_ns_ew_3_1     ref_gnd die_model_isolate
* xblk_die_pkg_bump_ns_ew_3_2      pkg_bump_ns_ew_3_2     ref_gnd die_model_isolate
* xblk_die_pkg_bump_ns_ew_3_3      pkg_bump_ns_ew_3_3     ref_gnd die_model_isolate
* xblk_die_pkg_bump_ns_ew_3_4      pkg_bump_ns_ew_3_4     ref_gnd die_model_isolate
* xblk_die_pkg_bump_ns_ew_3_5      pkg_bump_ns_ew_3_5     ref_gnd die_model_isolate
* xblk_die_pkg_bump_ns_ew_3_6      pkg_bump_ns_ew_3_6     ref_gnd die_model_isolate
* xblk_die_pkg_bump_ns_ew_3_7      pkg_bump_ns_ew_3_7     ref_gnd die_model_isolate
* xblk_die_pkg_bump_ns_ew_4_0      pkg_bump_ns_ew_4_0     ref_gnd die_model_isolate
* xblk_die_pkg_bump_ns_ew_4_1      pkg_bump_ns_ew_4_1     ref_gnd die_model_isolate
* xblk_die_pkg_bump_ns_ew_4_2      pkg_bump_ns_ew_4_2     ref_gnd die_model_isolate
* xblk_die_pkg_bump_ns_ew_4_3      pkg_bump_ns_ew_4_3     ref_gnd die_model_isolate
* xblk_die_pkg_bump_ns_ew_4_4      pkg_bump_ns_ew_4_4     ref_gnd die_model_isolate
* xblk_die_pkg_bump_ns_ew_4_5      pkg_bump_ns_ew_4_5     ref_gnd die_model_isolate
* xblk_die_pkg_bump_ns_ew_4_6      pkg_bump_ns_ew_4_6     ref_gnd die_model_isolate
* xblk_die_pkg_bump_ns_ew_4_7      pkg_bump_ns_ew_4_7     ref_gnd die_model_isolate
* xblk_die_pkg_bump_ns_ew_5_0      pkg_bump_ns_ew_5_0     ref_gnd die_model_isolate
* xblk_die_pkg_bump_ns_ew_5_1      pkg_bump_ns_ew_5_1     ref_gnd die_model_isolate
* xblk_die_pkg_bump_ns_ew_5_2      pkg_bump_ns_ew_5_2     ref_gnd die_model_isolate
* xblk_die_pkg_bump_ns_ew_5_3      pkg_bump_ns_ew_5_3     ref_gnd die_model_isolate
* xblk_die_pkg_bump_ns_ew_5_4      pkg_bump_ns_ew_5_4     ref_gnd die_model_isolate
* xblk_die_pkg_bump_ns_ew_5_5      pkg_bump_ns_ew_5_5     ref_gnd die_model_isolate
* xblk_die_pkg_bump_ns_ew_5_6      pkg_bump_ns_ew_5_6     ref_gnd die_model_isolate
* xblk_die_pkg_bump_ns_ew_5_7      pkg_bump_ns_ew_5_7     ref_gnd die_model_isolate
* xblk_die_pkg_bump_ns_ew_6_0      pkg_bump_ns_ew_6_0     ref_gnd die_model_isolate
* xblk_die_pkg_bump_ns_ew_6_1      pkg_bump_ns_ew_6_1     ref_gnd die_model_isolate
* xblk_die_pkg_bump_ns_ew_6_2      pkg_bump_ns_ew_6_2     ref_gnd die_model_isolate
* xblk_die_pkg_bump_ns_ew_6_3      pkg_bump_ns_ew_6_3     ref_gnd die_model_isolate
* xblk_die_pkg_bump_ns_ew_6_4      pkg_bump_ns_ew_6_4     ref_gnd die_model_isolate
* xblk_die_pkg_bump_ns_ew_6_5      pkg_bump_ns_ew_6_5     ref_gnd die_model_isolate
* xblk_die_pkg_bump_ns_ew_6_6      pkg_bump_ns_ew_6_6     ref_gnd die_model_isolate
* xblk_die_pkg_bump_ns_ew_6_7      pkg_bump_ns_ew_6_7     ref_gnd die_model_isolate
* xblk_die_pkg_bump_ns_ew_7_0      pkg_bump_ns_ew_7_0     ref_gnd die_model_isolate
* xblk_die_pkg_bump_ns_ew_7_1      pkg_bump_ns_ew_7_1     ref_gnd die_model_isolate
* xblk_die_pkg_bump_ns_ew_7_2      pkg_bump_ns_ew_7_2     ref_gnd die_model_isolate
* xblk_die_pkg_bump_ns_ew_7_3      pkg_bump_ns_ew_7_3     ref_gnd die_model_isolate
* xblk_die_pkg_bump_ns_ew_7_4      pkg_bump_ns_ew_7_4     ref_gnd die_model_isolate
* xblk_die_pkg_bump_ns_ew_7_5      pkg_bump_ns_ew_7_5     ref_gnd die_model_isolate
* xblk_die_pkg_bump_ns_ew_7_6      pkg_bump_ns_ew_7_6     ref_gnd die_model_isolate
* xblk_die_pkg_bump_ns_ew_7_7      pkg_bump_ns_ew_7_7     ref_gnd die_model_isolate
* xblk_die_pkg_bump_ns_ew_8_0      pkg_bump_ns_ew_8_0     ref_gnd die_model_isolate
* xblk_die_pkg_bump_ns_ew_8_1      pkg_bump_ns_ew_8_1     ref_gnd die_model_isolate
* xblk_die_pkg_bump_ns_ew_8_2      pkg_bump_ns_ew_8_2     ref_gnd die_model_isolate
* xblk_die_pkg_bump_ns_ew_8_3      pkg_bump_ns_ew_8_3     ref_gnd die_model_isolate
* xblk_die_pkg_bump_ns_ew_8_4      pkg_bump_ns_ew_8_4     ref_gnd die_model_isolate
* xblk_die_pkg_bump_ns_ew_8_5      pkg_bump_ns_ew_8_5     ref_gnd die_model_isolate
* xblk_die_pkg_bump_ns_ew_8_6      pkg_bump_ns_ew_8_6     ref_gnd die_model_isolate
* xblk_die_pkg_bump_ns_ew_8_7      pkg_bump_ns_ew_8_7     ref_gnd die_model_isolate
* xblk_die_pkg_bump_ns_ew_9_0      pkg_bump_ns_ew_9_0     ref_gnd die_model_isolate
* xblk_die_pkg_bump_ns_ew_9_1      pkg_bump_ns_ew_9_1     ref_gnd die_model_isolate
* xblk_die_pkg_bump_ns_ew_9_2      pkg_bump_ns_ew_9_2     ref_gnd die_model_isolate
* xblk_die_pkg_bump_ns_ew_9_3      pkg_bump_ns_ew_9_3     ref_gnd die_model_isolate
* xblk_die_pkg_bump_ns_ew_9_4      pkg_bump_ns_ew_9_4     ref_gnd die_model_isolate
* xblk_die_pkg_bump_ns_ew_9_5      pkg_bump_ns_ew_9_5     ref_gnd die_model_isolate
* xblk_die_pkg_bump_ns_ew_9_6      pkg_bump_ns_ew_9_6     ref_gnd die_model_isolate
* xblk_die_pkg_bump_ns_ew_9_7      pkg_bump_ns_ew_9_7     ref_gnd die_model_isolate
* xblk_die_pkg_bump_ns_ew_10_0     pkg_bump_ns_ew_10_0    ref_gnd die_model_isolate
* xblk_die_pkg_bump_ns_ew_10_1     pkg_bump_ns_ew_10_1    ref_gnd die_model_isolate
* xblk_die_pkg_bump_ns_ew_10_2     pkg_bump_ns_ew_10_2    ref_gnd die_model_isolate
* xblk_die_pkg_bump_ns_ew_10_3     pkg_bump_ns_ew_10_3    ref_gnd die_model_isolate
* xblk_die_pkg_bump_ns_ew_10_4     pkg_bump_ns_ew_10_4    ref_gnd die_model_isolate
* xblk_die_pkg_bump_ns_ew_10_5     pkg_bump_ns_ew_10_5    ref_gnd die_model_isolate
* xblk_die_pkg_bump_ns_ew_10_6     pkg_bump_ns_ew_10_6    ref_gnd die_model_isolate
* xblk_die_pkg_bump_ns_ew_10_7     pkg_bump_ns_ew_10_7    ref_gnd die_model_isolate
* xblk_die_pkg_bump_ns_ew_11_0     pkg_bump_ns_ew_11_0    ref_gnd die_model_isolate
* xblk_die_pkg_bump_ns_ew_11_1     pkg_bump_ns_ew_11_1    ref_gnd die_model_isolate
* xblk_die_pkg_bump_ns_ew_11_2     pkg_bump_ns_ew_11_2    ref_gnd die_model_isolate
* xblk_die_pkg_bump_ns_ew_11_3     pkg_bump_ns_ew_11_3    ref_gnd die_model_isolate
* xblk_die_pkg_bump_ns_ew_11_4     pkg_bump_ns_ew_11_4    ref_gnd die_model_isolate
* xblk_die_pkg_bump_ns_ew_11_5     pkg_bump_ns_ew_11_5    ref_gnd die_model_isolate
* xblk_die_pkg_bump_ns_ew_11_6     pkg_bump_ns_ew_11_6    ref_gnd die_model_isolate
* xblk_die_pkg_bump_ns_ew_11_7     pkg_bump_ns_ew_11_7    ref_gnd die_model_isolate
* xblk_die_pkg_bump_ns_ew_12_0     pkg_bump_ns_ew_12_0    ref_gnd die_model_isolate
* xblk_die_pkg_bump_ns_ew_12_1     pkg_bump_ns_ew_12_1    ref_gnd die_model_isolate
* xblk_die_pkg_bump_ns_ew_12_2     pkg_bump_ns_ew_12_2    ref_gnd die_model_isolate
* xblk_die_pkg_bump_ns_ew_12_3     pkg_bump_ns_ew_12_3    ref_gnd die_model_isolate
* xblk_die_pkg_bump_ns_ew_12_4     pkg_bump_ns_ew_12_4    ref_gnd die_model_isolate
* xblk_die_pkg_bump_ns_ew_12_5     pkg_bump_ns_ew_12_5    ref_gnd die_model_isolate
* xblk_die_pkg_bump_ns_ew_12_6     pkg_bump_ns_ew_12_6    ref_gnd die_model_isolate
* xblk_die_pkg_bump_ns_ew_12_7     pkg_bump_ns_ew_12_7    ref_gnd die_model_isolate
* xblk_die_pkg_bump_ns_ew_13_0     pkg_bump_ns_ew_13_0    ref_gnd die_model_isolate
* xblk_die_pkg_bump_ns_ew_13_1     pkg_bump_ns_ew_13_1    ref_gnd die_model_isolate
* xblk_die_pkg_bump_ns_ew_13_2     pkg_bump_ns_ew_13_2    ref_gnd die_model_isolate
* xblk_die_pkg_bump_ns_ew_13_3     pkg_bump_ns_ew_13_3    ref_gnd die_model_isolate
* xblk_die_pkg_bump_ns_ew_13_4     pkg_bump_ns_ew_13_4    ref_gnd die_model_isolate
* xblk_die_pkg_bump_ns_ew_13_5     pkg_bump_ns_ew_13_5    ref_gnd die_model_isolate
* xblk_die_pkg_bump_ns_ew_13_6     pkg_bump_ns_ew_13_6    ref_gnd die_model_isolate
* xblk_die_pkg_bump_ns_ew_13_7     pkg_bump_ns_ew_13_7    ref_gnd die_model_isolate
* xblk_die_pkg_bump_ns_ew_14_0     pkg_bump_ns_ew_14_0    ref_gnd die_model_isolate
* xblk_die_pkg_bump_ns_ew_14_1     pkg_bump_ns_ew_14_1    ref_gnd die_model_isolate
* xblk_die_pkg_bump_ns_ew_14_2     pkg_bump_ns_ew_14_2    ref_gnd die_model_isolate
* xblk_die_pkg_bump_ns_ew_14_3     pkg_bump_ns_ew_14_3    ref_gnd die_model_isolate
* xblk_die_pkg_bump_ns_ew_14_4     pkg_bump_ns_ew_14_4    ref_gnd die_model_isolate
* xblk_die_pkg_bump_ns_ew_14_5     pkg_bump_ns_ew_14_5    ref_gnd die_model_isolate
* xblk_die_pkg_bump_ns_ew_14_6     pkg_bump_ns_ew_14_6    ref_gnd die_model_isolate
* xblk_die_pkg_bump_ns_ew_14_7     pkg_bump_ns_ew_14_7    ref_gnd die_model_isolate
* xblk_die_pkg_bump_ns_ew_15_0     pkg_bump_ns_ew_15_0    ref_gnd die_model_isolate
* xblk_die_pkg_bump_ns_ew_15_1     pkg_bump_ns_ew_15_1    ref_gnd die_model_isolate
* xblk_die_pkg_bump_ns_ew_15_2     pkg_bump_ns_ew_15_2    ref_gnd die_model_isolate
* xblk_die_pkg_bump_ns_ew_15_3     pkg_bump_ns_ew_15_3    ref_gnd die_model_isolate
* xblk_die_pkg_bump_ns_ew_15_4     pkg_bump_ns_ew_15_4    ref_gnd die_model_isolate
* xblk_die_pkg_bump_ns_ew_15_5     pkg_bump_ns_ew_15_5    ref_gnd die_model_isolate
* xblk_die_pkg_bump_ns_ew_15_6     pkg_bump_ns_ew_15_6    ref_gnd die_model_isolate
* xblk_die_pkg_bump_ns_ew_15_7     pkg_bump_ns_ew_15_7    ref_gnd die_model_isolate
* xblk_die_pkg_bump_ns_ew_16_0     pkg_bump_ns_ew_16_0    ref_gnd die_model_isolate
* xblk_die_pkg_bump_ns_ew_16_1     pkg_bump_ns_ew_16_1    ref_gnd die_model_isolate
* xblk_die_pkg_bump_ns_ew_16_2     pkg_bump_ns_ew_16_2    ref_gnd die_model_isolate
* xblk_die_pkg_bump_ns_ew_16_3     pkg_bump_ns_ew_16_3    ref_gnd die_model_isolate
* xblk_die_pkg_bump_ns_ew_16_4     pkg_bump_ns_ew_16_4    ref_gnd die_model_isolate
* xblk_die_pkg_bump_ns_ew_16_5     pkg_bump_ns_ew_16_5    ref_gnd die_model_isolate
* xblk_die_pkg_bump_ns_ew_16_6     pkg_bump_ns_ew_16_6    ref_gnd die_model_isolate
* xblk_die_pkg_bump_ns_ew_16_7     pkg_bump_ns_ew_16_7    ref_gnd die_model_isolate
* xblk_die_pkg_bump_ns_ew_17_0     pkg_bump_ns_ew_17_0    ref_gnd die_model_isolate
* xblk_die_pkg_bump_ns_ew_17_1     pkg_bump_ns_ew_17_1    ref_gnd die_model_isolate
* xblk_die_pkg_bump_ns_ew_17_2     pkg_bump_ns_ew_17_2    ref_gnd die_model_isolate
* xblk_die_pkg_bump_ns_ew_17_3     pkg_bump_ns_ew_17_3    ref_gnd die_model_isolate
* xblk_die_pkg_bump_ns_ew_17_4     pkg_bump_ns_ew_17_4    ref_gnd die_model_isolate
* xblk_die_pkg_bump_ns_ew_17_5     pkg_bump_ns_ew_17_5    ref_gnd die_model_isolate
* xblk_die_pkg_bump_ns_ew_17_6     pkg_bump_ns_ew_17_6    ref_gnd die_model_isolate
* xblk_die_pkg_bump_ns_ew_17_7     pkg_bump_ns_ew_17_7    ref_gnd die_model_isolate
* xblk_die_pkg_bump_ns_ew_18_0     pkg_bump_ns_ew_18_0    ref_gnd die_model_isolate
* xblk_die_pkg_bump_ns_ew_18_1     pkg_bump_ns_ew_18_1    ref_gnd die_model_isolate
* xblk_die_pkg_bump_ns_ew_18_2     pkg_bump_ns_ew_18_2    ref_gnd die_model_isolate
* xblk_die_pkg_bump_ns_ew_18_3     pkg_bump_ns_ew_18_3    ref_gnd die_model_isolate
* xblk_die_pkg_bump_ns_ew_18_4     pkg_bump_ns_ew_18_4    ref_gnd die_model_isolate
* xblk_die_pkg_bump_ns_ew_18_5     pkg_bump_ns_ew_18_5    ref_gnd die_model_isolate
* xblk_die_pkg_bump_ns_ew_18_6     pkg_bump_ns_ew_18_6    ref_gnd die_model_isolate
* xblk_die_pkg_bump_ns_ew_18_7     pkg_bump_ns_ew_18_7    ref_gnd die_model_isolate
* xblk_die_pkg_bump_ns_ew_19_0     pkg_bump_ns_ew_19_0    ref_gnd die_model_isolate
* xblk_die_pkg_bump_ns_ew_19_1     pkg_bump_ns_ew_19_1    ref_gnd die_model_isolate
* xblk_die_pkg_bump_ns_ew_19_2     pkg_bump_ns_ew_19_2    ref_gnd die_model_isolate
* xblk_die_pkg_bump_ns_ew_19_3     pkg_bump_ns_ew_19_3    ref_gnd die_model_isolate
* xblk_die_pkg_bump_ns_ew_19_4     pkg_bump_ns_ew_19_4    ref_gnd die_model_isolate
* xblk_die_pkg_bump_ns_ew_19_5     pkg_bump_ns_ew_19_5    ref_gnd die_model_isolate
* xblk_die_pkg_bump_ns_ew_19_6     pkg_bump_ns_ew_19_6    ref_gnd die_model_isolate
* xblk_die_pkg_bump_ns_ew_19_7     pkg_bump_ns_ew_19_7    ref_gnd die_model_isolate
* xblk_die_pkg_bump_ns_ew_20_0     pkg_bump_ns_ew_20_0    ref_gnd die_model_isolate
* xblk_die_pkg_bump_ns_ew_20_1     pkg_bump_ns_ew_20_1    ref_gnd die_model_isolate
* xblk_die_pkg_bump_ns_ew_20_2     pkg_bump_ns_ew_20_2    ref_gnd die_model_isolate
* xblk_die_pkg_bump_ns_ew_20_3     pkg_bump_ns_ew_20_3    ref_gnd die_model_isolate
* xblk_die_pkg_bump_ns_ew_20_4     pkg_bump_ns_ew_20_4    ref_gnd die_model_isolate
* xblk_die_pkg_bump_ns_ew_20_5     pkg_bump_ns_ew_20_5    ref_gnd die_model_isolate
* xblk_die_pkg_bump_ns_ew_20_6     pkg_bump_ns_ew_20_6    ref_gnd die_model_isolate
* xblk_die_pkg_bump_ns_ew_20_7     pkg_bump_ns_ew_20_7    ref_gnd die_model_isolate
* xblk_die_pkg_bump_ns_ew_21_0     pkg_bump_ns_ew_21_0    ref_gnd die_model_isolate
* xblk_die_pkg_bump_ns_ew_21_1     pkg_bump_ns_ew_21_1    ref_gnd die_model_isolate
* xblk_die_pkg_bump_ns_ew_21_2     pkg_bump_ns_ew_21_2    ref_gnd die_model_isolate
* xblk_die_pkg_bump_ns_ew_21_3     pkg_bump_ns_ew_21_3    ref_gnd die_model_isolate
* xblk_die_pkg_bump_ns_ew_21_4     pkg_bump_ns_ew_21_4    ref_gnd die_model_isolate
* xblk_die_pkg_bump_ns_ew_21_5     pkg_bump_ns_ew_21_5    ref_gnd die_model_isolate
* xblk_die_pkg_bump_ns_ew_21_6     pkg_bump_ns_ew_21_6    ref_gnd die_model_isolate
* xblk_die_pkg_bump_ns_ew_21_7     pkg_bump_ns_ew_21_7    ref_gnd die_model_isolate
* xblk_die_pkg_bump_ns_ew_22_0     pkg_bump_ns_ew_22_0    ref_gnd die_model_isolate
* xblk_die_pkg_bump_ns_ew_22_1     pkg_bump_ns_ew_22_1    ref_gnd die_model_isolate
* xblk_die_pkg_bump_ns_ew_22_2     pkg_bump_ns_ew_22_2    ref_gnd die_model_isolate
* xblk_die_pkg_bump_ns_ew_22_3     pkg_bump_ns_ew_22_3    ref_gnd die_model_isolate
* xblk_die_pkg_bump_ns_ew_22_4     pkg_bump_ns_ew_22_4    ref_gnd die_model_isolate
* xblk_die_pkg_bump_ns_ew_22_5     pkg_bump_ns_ew_22_5    ref_gnd die_model_isolate
* xblk_die_pkg_bump_ns_ew_22_6     pkg_bump_ns_ew_22_6    ref_gnd die_model_isolate
* xblk_die_pkg_bump_ns_ew_22_7     pkg_bump_ns_ew_22_7    ref_gnd die_model_isolate
* xblk_die_pkg_bump_ns_ew_23_0     pkg_bump_ns_ew_23_0    ref_gnd die_model_isolate
* xblk_die_pkg_bump_ns_ew_23_1     pkg_bump_ns_ew_23_1    ref_gnd die_model_isolate
* xblk_die_pkg_bump_ns_ew_23_2     pkg_bump_ns_ew_23_2    ref_gnd die_model_isolate
* xblk_die_pkg_bump_ns_ew_23_3     pkg_bump_ns_ew_23_3    ref_gnd die_model_isolate
* xblk_die_pkg_bump_ns_ew_23_4     pkg_bump_ns_ew_23_4    ref_gnd die_model_isolate
* xblk_die_pkg_bump_ns_ew_23_5     pkg_bump_ns_ew_23_5    ref_gnd die_model_isolate
* xblk_die_pkg_bump_ns_ew_23_6     pkg_bump_ns_ew_23_6    ref_gnd die_model_isolate
* xblk_die_pkg_bump_ns_ew_23_7     pkg_bump_ns_ew_23_7    ref_gnd die_model_isolate
*** experiment end

.endif

*** experiment to add MIM, 3962nF in total
	.if (is_MIM_exp_24x8 == 1)
		* .param a_cmin = 20.63n    	*** 3962nF in total
		.param a_cmin = 206.3n		*** 10x MIM
		c_MIM_pkg_bump_ns_ew_0_0    pkg_bump_ns_ew_0_0     0   a_cmin
		c_MIM_pkg_bump_ns_ew_0_1    pkg_bump_ns_ew_0_1     0   a_cmin
		c_MIM_pkg_bump_ns_ew_0_2    pkg_bump_ns_ew_0_2     0   a_cmin
		c_MIM_pkg_bump_ns_ew_0_3    pkg_bump_ns_ew_0_3     0   a_cmin
		c_MIM_pkg_bump_ns_ew_0_4    pkg_bump_ns_ew_0_4     0   a_cmin
		c_MIM_pkg_bump_ns_ew_0_5    pkg_bump_ns_ew_0_5     0   a_cmin
		c_MIM_pkg_bump_ns_ew_0_6    pkg_bump_ns_ew_0_6     0   a_cmin
		c_MIM_pkg_bump_ns_ew_0_7    pkg_bump_ns_ew_0_7     0   a_cmin
		c_MIM_pkg_bump_ns_ew_1_0    pkg_bump_ns_ew_1_0     0   a_cmin
		c_MIM_pkg_bump_ns_ew_1_1    pkg_bump_ns_ew_1_1     0   a_cmin
		c_MIM_pkg_bump_ns_ew_1_2    pkg_bump_ns_ew_1_2     0   a_cmin
		c_MIM_pkg_bump_ns_ew_1_3    pkg_bump_ns_ew_1_3     0   a_cmin
		c_MIM_pkg_bump_ns_ew_1_4    pkg_bump_ns_ew_1_4     0   a_cmin
		c_MIM_pkg_bump_ns_ew_1_5    pkg_bump_ns_ew_1_5     0   a_cmin
		c_MIM_pkg_bump_ns_ew_1_6    pkg_bump_ns_ew_1_6     0   a_cmin
		c_MIM_pkg_bump_ns_ew_1_7    pkg_bump_ns_ew_1_7     0   a_cmin
		c_MIM_pkg_bump_ns_ew_2_0    pkg_bump_ns_ew_2_0     0   a_cmin
		c_MIM_pkg_bump_ns_ew_2_1    pkg_bump_ns_ew_2_1     0   a_cmin
		c_MIM_pkg_bump_ns_ew_2_2    pkg_bump_ns_ew_2_2     0   a_cmin
		c_MIM_pkg_bump_ns_ew_2_3    pkg_bump_ns_ew_2_3     0   a_cmin
		c_MIM_pkg_bump_ns_ew_2_4    pkg_bump_ns_ew_2_4     0   a_cmin
		c_MIM_pkg_bump_ns_ew_2_5    pkg_bump_ns_ew_2_5     0   a_cmin
		c_MIM_pkg_bump_ns_ew_2_6    pkg_bump_ns_ew_2_6     0   a_cmin
		c_MIM_pkg_bump_ns_ew_2_7    pkg_bump_ns_ew_2_7     0   a_cmin
		c_MIM_pkg_bump_ns_ew_3_0    pkg_bump_ns_ew_3_0     0   a_cmin
		c_MIM_pkg_bump_ns_ew_3_1    pkg_bump_ns_ew_3_1     0   a_cmin
		c_MIM_pkg_bump_ns_ew_3_2    pkg_bump_ns_ew_3_2     0   a_cmin
		c_MIM_pkg_bump_ns_ew_3_3    pkg_bump_ns_ew_3_3     0   a_cmin
		c_MIM_pkg_bump_ns_ew_3_4    pkg_bump_ns_ew_3_4     0   a_cmin
		c_MIM_pkg_bump_ns_ew_3_5    pkg_bump_ns_ew_3_5     0   a_cmin
		c_MIM_pkg_bump_ns_ew_3_6    pkg_bump_ns_ew_3_6     0   a_cmin
		c_MIM_pkg_bump_ns_ew_3_7    pkg_bump_ns_ew_3_7     0   a_cmin
		c_MIM_pkg_bump_ns_ew_4_0    pkg_bump_ns_ew_4_0     0   a_cmin
		c_MIM_pkg_bump_ns_ew_4_1    pkg_bump_ns_ew_4_1     0   a_cmin
		c_MIM_pkg_bump_ns_ew_4_2    pkg_bump_ns_ew_4_2     0   a_cmin
		c_MIM_pkg_bump_ns_ew_4_3    pkg_bump_ns_ew_4_3     0   a_cmin
		c_MIM_pkg_bump_ns_ew_4_4    pkg_bump_ns_ew_4_4     0   a_cmin
		c_MIM_pkg_bump_ns_ew_4_5    pkg_bump_ns_ew_4_5     0   a_cmin
		c_MIM_pkg_bump_ns_ew_4_6    pkg_bump_ns_ew_4_6     0   a_cmin
		c_MIM_pkg_bump_ns_ew_4_7    pkg_bump_ns_ew_4_7     0   a_cmin
		c_MIM_pkg_bump_ns_ew_5_0    pkg_bump_ns_ew_5_0     0   a_cmin
		c_MIM_pkg_bump_ns_ew_5_1    pkg_bump_ns_ew_5_1     0   a_cmin
		c_MIM_pkg_bump_ns_ew_5_2    pkg_bump_ns_ew_5_2     0   a_cmin
		c_MIM_pkg_bump_ns_ew_5_3    pkg_bump_ns_ew_5_3     0   a_cmin
		c_MIM_pkg_bump_ns_ew_5_4    pkg_bump_ns_ew_5_4     0   a_cmin
		c_MIM_pkg_bump_ns_ew_5_5    pkg_bump_ns_ew_5_5     0   a_cmin
		c_MIM_pkg_bump_ns_ew_5_6    pkg_bump_ns_ew_5_6     0   a_cmin
		c_MIM_pkg_bump_ns_ew_5_7    pkg_bump_ns_ew_5_7     0   a_cmin
		c_MIM_pkg_bump_ns_ew_6_0    pkg_bump_ns_ew_6_0     0   a_cmin
		c_MIM_pkg_bump_ns_ew_6_1    pkg_bump_ns_ew_6_1     0   a_cmin
		c_MIM_pkg_bump_ns_ew_6_2    pkg_bump_ns_ew_6_2     0   a_cmin
		c_MIM_pkg_bump_ns_ew_6_3    pkg_bump_ns_ew_6_3     0   a_cmin
		c_MIM_pkg_bump_ns_ew_6_4    pkg_bump_ns_ew_6_4     0   a_cmin
		c_MIM_pkg_bump_ns_ew_6_5    pkg_bump_ns_ew_6_5     0   a_cmin
		c_MIM_pkg_bump_ns_ew_6_6    pkg_bump_ns_ew_6_6     0   a_cmin
		c_MIM_pkg_bump_ns_ew_6_7    pkg_bump_ns_ew_6_7     0   a_cmin
		c_MIM_pkg_bump_ns_ew_7_0    pkg_bump_ns_ew_7_0     0   a_cmin
		c_MIM_pkg_bump_ns_ew_7_1    pkg_bump_ns_ew_7_1     0   a_cmin
		c_MIM_pkg_bump_ns_ew_7_2    pkg_bump_ns_ew_7_2     0   a_cmin
		c_MIM_pkg_bump_ns_ew_7_3    pkg_bump_ns_ew_7_3     0   a_cmin
		c_MIM_pkg_bump_ns_ew_7_4    pkg_bump_ns_ew_7_4     0   a_cmin
		c_MIM_pkg_bump_ns_ew_7_5    pkg_bump_ns_ew_7_5     0   a_cmin
		c_MIM_pkg_bump_ns_ew_7_6    pkg_bump_ns_ew_7_6     0   a_cmin
		c_MIM_pkg_bump_ns_ew_7_7    pkg_bump_ns_ew_7_7     0   a_cmin
		c_MIM_pkg_bump_ns_ew_8_0    pkg_bump_ns_ew_8_0     0   a_cmin
		c_MIM_pkg_bump_ns_ew_8_1    pkg_bump_ns_ew_8_1     0   a_cmin
		c_MIM_pkg_bump_ns_ew_8_2    pkg_bump_ns_ew_8_2     0   a_cmin
		c_MIM_pkg_bump_ns_ew_8_3    pkg_bump_ns_ew_8_3     0   a_cmin
		c_MIM_pkg_bump_ns_ew_8_4    pkg_bump_ns_ew_8_4     0   a_cmin
		c_MIM_pkg_bump_ns_ew_8_5    pkg_bump_ns_ew_8_5     0   a_cmin
		c_MIM_pkg_bump_ns_ew_8_6    pkg_bump_ns_ew_8_6     0   a_cmin
		c_MIM_pkg_bump_ns_ew_8_7    pkg_bump_ns_ew_8_7     0   a_cmin
		c_MIM_pkg_bump_ns_ew_9_0    pkg_bump_ns_ew_9_0     0   a_cmin
		c_MIM_pkg_bump_ns_ew_9_1    pkg_bump_ns_ew_9_1     0   a_cmin
		c_MIM_pkg_bump_ns_ew_9_2    pkg_bump_ns_ew_9_2     0   a_cmin
		c_MIM_pkg_bump_ns_ew_9_3    pkg_bump_ns_ew_9_3     0   a_cmin
		c_MIM_pkg_bump_ns_ew_9_4    pkg_bump_ns_ew_9_4     0   a_cmin
		c_MIM_pkg_bump_ns_ew_9_5    pkg_bump_ns_ew_9_5     0   a_cmin
		c_MIM_pkg_bump_ns_ew_9_6    pkg_bump_ns_ew_9_6     0   a_cmin
		c_MIM_pkg_bump_ns_ew_9_7    pkg_bump_ns_ew_9_7     0   a_cmin
		c_MIM_pkg_bump_ns_ew_10_0   pkg_bump_ns_ew_10_0    0   a_cmin
		c_MIM_pkg_bump_ns_ew_10_1   pkg_bump_ns_ew_10_1    0   a_cmin
		c_MIM_pkg_bump_ns_ew_10_2   pkg_bump_ns_ew_10_2    0   a_cmin
		c_MIM_pkg_bump_ns_ew_10_3   pkg_bump_ns_ew_10_3    0   a_cmin
		c_MIM_pkg_bump_ns_ew_10_4   pkg_bump_ns_ew_10_4    0   a_cmin
		c_MIM_pkg_bump_ns_ew_10_5   pkg_bump_ns_ew_10_5    0   a_cmin
		c_MIM_pkg_bump_ns_ew_10_6   pkg_bump_ns_ew_10_6    0   a_cmin
		c_MIM_pkg_bump_ns_ew_10_7   pkg_bump_ns_ew_10_7    0   a_cmin
		c_MIM_pkg_bump_ns_ew_11_0   pkg_bump_ns_ew_11_0    0   a_cmin
		c_MIM_pkg_bump_ns_ew_11_1   pkg_bump_ns_ew_11_1    0   a_cmin
		c_MIM_pkg_bump_ns_ew_11_2   pkg_bump_ns_ew_11_2    0   a_cmin
		c_MIM_pkg_bump_ns_ew_11_3   pkg_bump_ns_ew_11_3    0   a_cmin
		c_MIM_pkg_bump_ns_ew_11_4   pkg_bump_ns_ew_11_4    0   a_cmin
		c_MIM_pkg_bump_ns_ew_11_5   pkg_bump_ns_ew_11_5    0   a_cmin
		c_MIM_pkg_bump_ns_ew_11_6   pkg_bump_ns_ew_11_6    0   a_cmin
		c_MIM_pkg_bump_ns_ew_11_7   pkg_bump_ns_ew_11_7    0   a_cmin
		c_MIM_pkg_bump_ns_ew_12_0   pkg_bump_ns_ew_12_0    0   a_cmin
		c_MIM_pkg_bump_ns_ew_12_1   pkg_bump_ns_ew_12_1    0   a_cmin
		c_MIM_pkg_bump_ns_ew_12_2   pkg_bump_ns_ew_12_2    0   a_cmin
		c_MIM_pkg_bump_ns_ew_12_3   pkg_bump_ns_ew_12_3    0   a_cmin
		c_MIM_pkg_bump_ns_ew_12_4   pkg_bump_ns_ew_12_4    0   a_cmin
		c_MIM_pkg_bump_ns_ew_12_5   pkg_bump_ns_ew_12_5    0   a_cmin
		c_MIM_pkg_bump_ns_ew_12_6   pkg_bump_ns_ew_12_6    0   a_cmin
		c_MIM_pkg_bump_ns_ew_12_7   pkg_bump_ns_ew_12_7    0   a_cmin
		c_MIM_pkg_bump_ns_ew_13_0   pkg_bump_ns_ew_13_0    0   a_cmin
		c_MIM_pkg_bump_ns_ew_13_1   pkg_bump_ns_ew_13_1    0   a_cmin
		c_MIM_pkg_bump_ns_ew_13_2   pkg_bump_ns_ew_13_2    0   a_cmin
		c_MIM_pkg_bump_ns_ew_13_3   pkg_bump_ns_ew_13_3    0   a_cmin
		c_MIM_pkg_bump_ns_ew_13_4   pkg_bump_ns_ew_13_4    0   a_cmin
		c_MIM_pkg_bump_ns_ew_13_5   pkg_bump_ns_ew_13_5    0   a_cmin
		c_MIM_pkg_bump_ns_ew_13_6   pkg_bump_ns_ew_13_6    0   a_cmin
		c_MIM_pkg_bump_ns_ew_13_7   pkg_bump_ns_ew_13_7    0   a_cmin
		c_MIM_pkg_bump_ns_ew_14_0   pkg_bump_ns_ew_14_0    0   a_cmin
		c_MIM_pkg_bump_ns_ew_14_1   pkg_bump_ns_ew_14_1    0   a_cmin
		c_MIM_pkg_bump_ns_ew_14_2   pkg_bump_ns_ew_14_2    0   a_cmin
		c_MIM_pkg_bump_ns_ew_14_3   pkg_bump_ns_ew_14_3    0   a_cmin
		c_MIM_pkg_bump_ns_ew_14_4   pkg_bump_ns_ew_14_4    0   a_cmin
		c_MIM_pkg_bump_ns_ew_14_5   pkg_bump_ns_ew_14_5    0   a_cmin
		c_MIM_pkg_bump_ns_ew_14_6   pkg_bump_ns_ew_14_6    0   a_cmin
		c_MIM_pkg_bump_ns_ew_14_7   pkg_bump_ns_ew_14_7    0   a_cmin
		c_MIM_pkg_bump_ns_ew_15_0   pkg_bump_ns_ew_15_0    0   a_cmin
		c_MIM_pkg_bump_ns_ew_15_1   pkg_bump_ns_ew_15_1    0   a_cmin
		c_MIM_pkg_bump_ns_ew_15_2   pkg_bump_ns_ew_15_2    0   a_cmin
		c_MIM_pkg_bump_ns_ew_15_3   pkg_bump_ns_ew_15_3    0   a_cmin
		c_MIM_pkg_bump_ns_ew_15_4   pkg_bump_ns_ew_15_4    0   a_cmin
		c_MIM_pkg_bump_ns_ew_15_5   pkg_bump_ns_ew_15_5    0   a_cmin
		c_MIM_pkg_bump_ns_ew_15_6   pkg_bump_ns_ew_15_6    0   a_cmin
		c_MIM_pkg_bump_ns_ew_15_7   pkg_bump_ns_ew_15_7    0   a_cmin
		c_MIM_pkg_bump_ns_ew_16_0   pkg_bump_ns_ew_16_0    0   a_cmin
		c_MIM_pkg_bump_ns_ew_16_1   pkg_bump_ns_ew_16_1    0   a_cmin
		c_MIM_pkg_bump_ns_ew_16_2   pkg_bump_ns_ew_16_2    0   a_cmin
		c_MIM_pkg_bump_ns_ew_16_3   pkg_bump_ns_ew_16_3    0   a_cmin
		c_MIM_pkg_bump_ns_ew_16_4   pkg_bump_ns_ew_16_4    0   a_cmin
		c_MIM_pkg_bump_ns_ew_16_5   pkg_bump_ns_ew_16_5    0   a_cmin
		c_MIM_pkg_bump_ns_ew_16_6   pkg_bump_ns_ew_16_6    0   a_cmin
		c_MIM_pkg_bump_ns_ew_16_7   pkg_bump_ns_ew_16_7    0   a_cmin
		c_MIM_pkg_bump_ns_ew_17_0   pkg_bump_ns_ew_17_0    0   a_cmin
		c_MIM_pkg_bump_ns_ew_17_1   pkg_bump_ns_ew_17_1    0   a_cmin
		c_MIM_pkg_bump_ns_ew_17_2   pkg_bump_ns_ew_17_2    0   a_cmin
		c_MIM_pkg_bump_ns_ew_17_3   pkg_bump_ns_ew_17_3    0   a_cmin
		c_MIM_pkg_bump_ns_ew_17_4   pkg_bump_ns_ew_17_4    0   a_cmin
		c_MIM_pkg_bump_ns_ew_17_5   pkg_bump_ns_ew_17_5    0   a_cmin
		c_MIM_pkg_bump_ns_ew_17_6   pkg_bump_ns_ew_17_6    0   a_cmin
		c_MIM_pkg_bump_ns_ew_17_7   pkg_bump_ns_ew_17_7    0   a_cmin
		c_MIM_pkg_bump_ns_ew_18_0   pkg_bump_ns_ew_18_0    0   a_cmin
		c_MIM_pkg_bump_ns_ew_18_1   pkg_bump_ns_ew_18_1    0   a_cmin
		c_MIM_pkg_bump_ns_ew_18_2   pkg_bump_ns_ew_18_2    0   a_cmin
		c_MIM_pkg_bump_ns_ew_18_3   pkg_bump_ns_ew_18_3    0   a_cmin
		c_MIM_pkg_bump_ns_ew_18_4   pkg_bump_ns_ew_18_4    0   a_cmin
		c_MIM_pkg_bump_ns_ew_18_5   pkg_bump_ns_ew_18_5    0   a_cmin
		c_MIM_pkg_bump_ns_ew_18_6   pkg_bump_ns_ew_18_6    0   a_cmin
		c_MIM_pkg_bump_ns_ew_18_7   pkg_bump_ns_ew_18_7    0   a_cmin
		c_MIM_pkg_bump_ns_ew_19_0   pkg_bump_ns_ew_19_0    0   a_cmin
		c_MIM_pkg_bump_ns_ew_19_1   pkg_bump_ns_ew_19_1    0   a_cmin
		c_MIM_pkg_bump_ns_ew_19_2   pkg_bump_ns_ew_19_2    0   a_cmin
		c_MIM_pkg_bump_ns_ew_19_3   pkg_bump_ns_ew_19_3    0   a_cmin
		c_MIM_pkg_bump_ns_ew_19_4   pkg_bump_ns_ew_19_4    0   a_cmin
		c_MIM_pkg_bump_ns_ew_19_5   pkg_bump_ns_ew_19_5    0   a_cmin
		c_MIM_pkg_bump_ns_ew_19_6   pkg_bump_ns_ew_19_6    0   a_cmin
		c_MIM_pkg_bump_ns_ew_19_7   pkg_bump_ns_ew_19_7    0   a_cmin
		c_MIM_pkg_bump_ns_ew_20_0   pkg_bump_ns_ew_20_0    0   a_cmin
		c_MIM_pkg_bump_ns_ew_20_1   pkg_bump_ns_ew_20_1    0   a_cmin
		c_MIM_pkg_bump_ns_ew_20_2   pkg_bump_ns_ew_20_2    0   a_cmin
		c_MIM_pkg_bump_ns_ew_20_3   pkg_bump_ns_ew_20_3    0   a_cmin
		c_MIM_pkg_bump_ns_ew_20_4   pkg_bump_ns_ew_20_4    0   a_cmin
		c_MIM_pkg_bump_ns_ew_20_5   pkg_bump_ns_ew_20_5    0   a_cmin
		c_MIM_pkg_bump_ns_ew_20_6   pkg_bump_ns_ew_20_6    0   a_cmin
		c_MIM_pkg_bump_ns_ew_20_7   pkg_bump_ns_ew_20_7    0   a_cmin
		c_MIM_pkg_bump_ns_ew_21_0   pkg_bump_ns_ew_21_0    0   a_cmin
		c_MIM_pkg_bump_ns_ew_21_1   pkg_bump_ns_ew_21_1    0   a_cmin
		c_MIM_pkg_bump_ns_ew_21_2   pkg_bump_ns_ew_21_2    0   a_cmin
		c_MIM_pkg_bump_ns_ew_21_3   pkg_bump_ns_ew_21_3    0   a_cmin
		c_MIM_pkg_bump_ns_ew_21_4   pkg_bump_ns_ew_21_4    0   a_cmin
		c_MIM_pkg_bump_ns_ew_21_5   pkg_bump_ns_ew_21_5    0   a_cmin
		c_MIM_pkg_bump_ns_ew_21_6   pkg_bump_ns_ew_21_6    0   a_cmin
		c_MIM_pkg_bump_ns_ew_21_7   pkg_bump_ns_ew_21_7    0   a_cmin
		c_MIM_pkg_bump_ns_ew_22_0   pkg_bump_ns_ew_22_0    0   a_cmin
		c_MIM_pkg_bump_ns_ew_22_1   pkg_bump_ns_ew_22_1    0   a_cmin
		c_MIM_pkg_bump_ns_ew_22_2   pkg_bump_ns_ew_22_2    0   a_cmin
		c_MIM_pkg_bump_ns_ew_22_3   pkg_bump_ns_ew_22_3    0   a_cmin
		c_MIM_pkg_bump_ns_ew_22_4   pkg_bump_ns_ew_22_4    0   a_cmin
		c_MIM_pkg_bump_ns_ew_22_5   pkg_bump_ns_ew_22_5    0   a_cmin
		c_MIM_pkg_bump_ns_ew_22_6   pkg_bump_ns_ew_22_6    0   a_cmin
		c_MIM_pkg_bump_ns_ew_22_7   pkg_bump_ns_ew_22_7    0   a_cmin
		c_MIM_pkg_bump_ns_ew_23_0   pkg_bump_ns_ew_23_0    0   a_cmin
		c_MIM_pkg_bump_ns_ew_23_1   pkg_bump_ns_ew_23_1    0   a_cmin
		c_MIM_pkg_bump_ns_ew_23_2   pkg_bump_ns_ew_23_2    0   a_cmin
		c_MIM_pkg_bump_ns_ew_23_3   pkg_bump_ns_ew_23_3    0   a_cmin
		c_MIM_pkg_bump_ns_ew_23_4   pkg_bump_ns_ew_23_4    0   a_cmin
		c_MIM_pkg_bump_ns_ew_23_5   pkg_bump_ns_ew_23_5    0   a_cmin
		c_MIM_pkg_bump_ns_ew_23_6   pkg_bump_ns_ew_23_6    0   a_cmin
		c_MIM_pkg_bump_ns_ew_23_7   pkg_bump_ns_ew_23_7    0   a_cmin
	.endif

* .if (is_use_MIM == 1)
	* xblk_die 	*** 4x8 NNE grp, Andes CPM w/MIM
	* +         pkg_bump_MA_ns_ew_0_0
	* + ref_gnd pkg_bump_MA_ns_ew_1_0
	* + ref_gnd pkg_bump_MA_ns_ew_2_0
	* + ref_gnd pkg_bump_MA_ns_ew_3_0
	* + ref_gnd pkg_bump_MA_ns_ew_0_1
	* + ref_gnd pkg_bump_MA_ns_ew_1_1
	* + ref_gnd pkg_bump_MA_ns_ew_2_1
	* + ref_gnd pkg_bump_MA_ns_ew_3_1
	* + ref_gnd pkg_bump_MA_ns_ew_0_2
	* + ref_gnd pkg_bump_MA_ns_ew_1_2
	* + ref_gnd pkg_bump_MA_ns_ew_2_2
	* + ref_gnd pkg_bump_MA_ns_ew_3_2
	* + ref_gnd pkg_bump_MA_ns_ew_0_3
	* + ref_gnd pkg_bump_MA_ns_ew_1_3
	* + ref_gnd pkg_bump_MA_ns_ew_2_3
	* + ref_gnd pkg_bump_MA_ns_ew_3_3
	* + ref_gnd pkg_bump_PA_ns_ew_0_4
	* + ref_gnd pkg_bump_PA_ns_ew_1_4
	* + ref_gnd pkg_bump_PA_ns_ew_2_4
	* + ref_gnd pkg_bump_PA_ns_ew_3_4
	* + ref_gnd pkg_bump_PA_ns_ew_0_5
	* + ref_gnd pkg_bump_PA_ns_ew_1_5
	* + ref_gnd pkg_bump_PA_ns_ew_2_5
	* + ref_gnd pkg_bump_PA_ns_ew_3_5
	* + ref_gnd pkg_bump_PA_ns_ew_0_6
	* + ref_gnd pkg_bump_PA_ns_ew_1_6
	* + ref_gnd pkg_bump_PA_ns_ew_2_6
	* + ref_gnd pkg_bump_PA_ns_ew_3_6
	* + ref_gnd pkg_bump_PA_ns_ew_0_7
	* + ref_gnd pkg_bump_PA_ns_ew_1_7
	* + ref_gnd pkg_bump_PA_ns_ew_2_7
	* + ref_gnd pkg_bump_PA_ns_ew_3_7
	* + ref_gnd
	* + adsPowerModel_NNE_4x8_w_MIM_240920_modelOnly

* .endif

*** current src

.if (is_curr_defined_external == 0)
	Icurr_pkg_bump_ns_ew_0_0     pkg_bump_ns_ew_0_0		ref_gnd   pwlfile = str( pwl_file_in_MA_1_tile )
	Icurr_pkg_bump_ns_ew_0_1     pkg_bump_ns_ew_0_1     ref_gnd   pwlfile = str( pwl_file_in_MA_1_tile )
	Icurr_pkg_bump_ns_ew_0_2     pkg_bump_ns_ew_0_2     ref_gnd   pwlfile = str( pwl_file_in_MA_1_tile )
	Icurr_pkg_bump_ns_ew_0_3     pkg_bump_ns_ew_0_3     ref_gnd   pwlfile = str( pwl_file_in_MA_1_tile )
	Icurr_pkg_bump_ns_ew_0_4     pkg_bump_ns_ew_0_4     ref_gnd   pwlfile = str( pwl_file_in_PA_1_tile )
	Icurr_pkg_bump_ns_ew_0_5     pkg_bump_ns_ew_0_5     ref_gnd   pwlfile = str( pwl_file_in_PA_1_tile )
	Icurr_pkg_bump_ns_ew_0_6     pkg_bump_ns_ew_0_6     ref_gnd   pwlfile = str( pwl_file_in_PA_1_tile )
	Icurr_pkg_bump_ns_ew_0_7     pkg_bump_ns_ew_0_7     ref_gnd   pwlfile = str( pwl_file_in_PA_1_tile )		*** north west corner
	Icurr_pkg_bump_ns_ew_1_0     pkg_bump_ns_ew_1_0     ref_gnd   pwlfile = str( pwl_file_in_MA_1_tile )
	Icurr_pkg_bump_ns_ew_1_1     pkg_bump_ns_ew_1_1     ref_gnd   pwlfile = str( pwl_file_in_MA_1_tile )
	Icurr_pkg_bump_ns_ew_1_2     pkg_bump_ns_ew_1_2     ref_gnd   pwlfile = str( pwl_file_in_MA_1_tile )
	Icurr_pkg_bump_ns_ew_1_3     pkg_bump_ns_ew_1_3     ref_gnd   pwlfile = str( pwl_file_in_MA_1_tile )
	Icurr_pkg_bump_ns_ew_1_4     pkg_bump_ns_ew_1_4     ref_gnd   pwlfile = str( pwl_file_in_PA_1_tile )
	Icurr_pkg_bump_ns_ew_1_5     pkg_bump_ns_ew_1_5     ref_gnd   pwlfile = str( pwl_file_in_PA_1_tile )
	Icurr_pkg_bump_ns_ew_1_6     pkg_bump_ns_ew_1_6     ref_gnd   pwlfile = str( pwl_file_in_PA_1_tile )
	Icurr_pkg_bump_ns_ew_1_7     pkg_bump_ns_ew_1_7     ref_gnd   pwlfile = str( pwl_file_in_PA_1_tile )
	Icurr_pkg_bump_ns_ew_2_0     pkg_bump_ns_ew_2_0     ref_gnd   pwlfile = str( pwl_file_in_MA_1_tile )
	Icurr_pkg_bump_ns_ew_2_1     pkg_bump_ns_ew_2_1     ref_gnd   pwlfile = str( pwl_file_in_MA_1_tile )
	Icurr_pkg_bump_ns_ew_2_2     pkg_bump_ns_ew_2_2     ref_gnd   pwlfile = str( pwl_file_in_MA_1_tile )
	Icurr_pkg_bump_ns_ew_2_3     pkg_bump_ns_ew_2_3     ref_gnd   pwlfile = str( pwl_file_in_MA_1_tile )
	Icurr_pkg_bump_ns_ew_2_4     pkg_bump_ns_ew_2_4     ref_gnd   pwlfile = str( pwl_file_in_PA_1_tile )
	Icurr_pkg_bump_ns_ew_2_5     pkg_bump_ns_ew_2_5     ref_gnd   pwlfile = str( pwl_file_in_PA_1_tile )
	Icurr_pkg_bump_ns_ew_2_6     pkg_bump_ns_ew_2_6     ref_gnd   pwlfile = str( pwl_file_in_PA_1_tile )
	Icurr_pkg_bump_ns_ew_2_7     pkg_bump_ns_ew_2_7     ref_gnd   pwlfile = str( pwl_file_in_PA_1_tile )
	Icurr_pkg_bump_ns_ew_3_0     pkg_bump_ns_ew_3_0     ref_gnd   pwlfile = str( pwl_file_in_MA_1_tile )
	Icurr_pkg_bump_ns_ew_3_1     pkg_bump_ns_ew_3_1     ref_gnd   pwlfile = str( pwl_file_in_MA_1_tile )
	Icurr_pkg_bump_ns_ew_3_2     pkg_bump_ns_ew_3_2     ref_gnd   pwlfile = str( pwl_file_in_MA_1_tile )
	Icurr_pkg_bump_ns_ew_3_3     pkg_bump_ns_ew_3_3     ref_gnd   pwlfile = str( pwl_file_in_MA_1_tile )
	Icurr_pkg_bump_ns_ew_3_4     pkg_bump_ns_ew_3_4     ref_gnd   pwlfile = str( pwl_file_in_PA_1_tile )
	Icurr_pkg_bump_ns_ew_3_5     pkg_bump_ns_ew_3_5     ref_gnd   pwlfile = str( pwl_file_in_PA_1_tile )
	Icurr_pkg_bump_ns_ew_3_6     pkg_bump_ns_ew_3_6     ref_gnd   pwlfile = str( pwl_file_in_PA_1_tile )
	Icurr_pkg_bump_ns_ew_3_7     pkg_bump_ns_ew_3_7     ref_gnd   pwlfile = str( pwl_file_in_PA_1_tile )
	Icurr_pkg_bump_ns_ew_4_0     pkg_bump_ns_ew_4_0     ref_gnd   pwlfile = str( pwl_file_in_MA_1_tile )
	Icurr_pkg_bump_ns_ew_4_1     pkg_bump_ns_ew_4_1     ref_gnd   pwlfile = str( pwl_file_in_MA_1_tile )
	Icurr_pkg_bump_ns_ew_4_2     pkg_bump_ns_ew_4_2     ref_gnd   pwlfile = str( pwl_file_in_MA_1_tile )
	Icurr_pkg_bump_ns_ew_4_3     pkg_bump_ns_ew_4_3     ref_gnd   pwlfile = str( pwl_file_in_MA_1_tile )
	Icurr_pkg_bump_ns_ew_4_4     pkg_bump_ns_ew_4_4     ref_gnd   pwlfile = str( pwl_file_in_PA_1_tile )
	Icurr_pkg_bump_ns_ew_4_5     pkg_bump_ns_ew_4_5     ref_gnd   pwlfile = str( pwl_file_in_PA_1_tile )
	Icurr_pkg_bump_ns_ew_4_6     pkg_bump_ns_ew_4_6     ref_gnd   pwlfile = str( pwl_file_in_PA_1_tile )
	Icurr_pkg_bump_ns_ew_4_7     pkg_bump_ns_ew_4_7     ref_gnd   pwlfile = str( pwl_file_in_PA_1_tile )
	Icurr_pkg_bump_ns_ew_5_0     pkg_bump_ns_ew_5_0     ref_gnd   pwlfile = str( pwl_file_in_MA_1_tile )
	Icurr_pkg_bump_ns_ew_5_1     pkg_bump_ns_ew_5_1     ref_gnd   pwlfile = str( pwl_file_in_MA_1_tile )
	Icurr_pkg_bump_ns_ew_5_2     pkg_bump_ns_ew_5_2     ref_gnd   pwlfile = str( pwl_file_in_MA_1_tile )
	Icurr_pkg_bump_ns_ew_5_3     pkg_bump_ns_ew_5_3     ref_gnd   pwlfile = str( pwl_file_in_MA_1_tile )
	Icurr_pkg_bump_ns_ew_5_4     pkg_bump_ns_ew_5_4     ref_gnd   pwlfile = str( pwl_file_in_PA_1_tile )
	Icurr_pkg_bump_ns_ew_5_5     pkg_bump_ns_ew_5_5     ref_gnd   pwlfile = str( pwl_file_in_PA_1_tile )
	Icurr_pkg_bump_ns_ew_5_6     pkg_bump_ns_ew_5_6     ref_gnd   pwlfile = str( pwl_file_in_PA_1_tile )
	Icurr_pkg_bump_ns_ew_5_7     pkg_bump_ns_ew_5_7     ref_gnd   pwlfile = str( pwl_file_in_PA_1_tile )

	Icurr_pkg_bump_ns_ew_6_0     pkg_bump_ns_ew_6_0     ref_gnd   curr_backgnd_MA_1_tile    * pwlfile = str(  )
	Icurr_pkg_bump_ns_ew_6_1     pkg_bump_ns_ew_6_1     ref_gnd   curr_backgnd_MA_1_tile    * pwlfile = str(  )
	Icurr_pkg_bump_ns_ew_6_2     pkg_bump_ns_ew_6_2     ref_gnd   curr_backgnd_MA_1_tile    * pwlfile = str(  )
	Icurr_pkg_bump_ns_ew_6_3     pkg_bump_ns_ew_6_3     ref_gnd   curr_backgnd_MA_1_tile    * pwlfile = str(  )
	Icurr_pkg_bump_ns_ew_6_4     pkg_bump_ns_ew_6_4     ref_gnd   curr_backgnd_PA_1_tile    * pwlfile = str(  )
	Icurr_pkg_bump_ns_ew_6_5     pkg_bump_ns_ew_6_5     ref_gnd   curr_backgnd_PA_1_tile    * pwlfile = str(  )
	Icurr_pkg_bump_ns_ew_6_6     pkg_bump_ns_ew_6_6     ref_gnd   curr_backgnd_PA_1_tile    * pwlfile = str(  )
	Icurr_pkg_bump_ns_ew_6_7     pkg_bump_ns_ew_6_7     ref_gnd   curr_backgnd_PA_1_tile    * pwlfile = str(  )
	Icurr_pkg_bump_ns_ew_7_0     pkg_bump_ns_ew_7_0     ref_gnd   curr_backgnd_MA_1_tile    * pwlfile = str(  )
	Icurr_pkg_bump_ns_ew_7_1     pkg_bump_ns_ew_7_1     ref_gnd   curr_backgnd_MA_1_tile    * pwlfile = str(  )
	Icurr_pkg_bump_ns_ew_7_2     pkg_bump_ns_ew_7_2     ref_gnd   curr_backgnd_MA_1_tile    * pwlfile = str(  )
	Icurr_pkg_bump_ns_ew_7_3     pkg_bump_ns_ew_7_3     ref_gnd   curr_backgnd_MA_1_tile    * pwlfile = str(  )
	Icurr_pkg_bump_ns_ew_7_4     pkg_bump_ns_ew_7_4     ref_gnd   curr_backgnd_PA_1_tile    * pwlfile = str(  )
	Icurr_pkg_bump_ns_ew_7_5     pkg_bump_ns_ew_7_5     ref_gnd   curr_backgnd_PA_1_tile    * pwlfile = str(  )
	Icurr_pkg_bump_ns_ew_7_6     pkg_bump_ns_ew_7_6     ref_gnd   curr_backgnd_PA_1_tile    * pwlfile = str(  )
	Icurr_pkg_bump_ns_ew_7_7     pkg_bump_ns_ew_7_7     ref_gnd   curr_backgnd_PA_1_tile    * pwlfile = str(  )
	Icurr_pkg_bump_ns_ew_8_0     pkg_bump_ns_ew_8_0     ref_gnd   curr_backgnd_MA_1_tile    * pwlfile = str(  )
	Icurr_pkg_bump_ns_ew_8_1     pkg_bump_ns_ew_8_1     ref_gnd   curr_backgnd_MA_1_tile    * pwlfile = str(  )
	Icurr_pkg_bump_ns_ew_8_2     pkg_bump_ns_ew_8_2     ref_gnd   curr_backgnd_MA_1_tile    * pwlfile = str(  )
	Icurr_pkg_bump_ns_ew_8_3     pkg_bump_ns_ew_8_3     ref_gnd   curr_backgnd_MA_1_tile    * pwlfile = str(  )
	Icurr_pkg_bump_ns_ew_8_4     pkg_bump_ns_ew_8_4     ref_gnd   curr_backgnd_PA_1_tile    * pwlfile = str(  )
	Icurr_pkg_bump_ns_ew_8_5     pkg_bump_ns_ew_8_5     ref_gnd   curr_backgnd_PA_1_tile    * pwlfile = str(  )
	Icurr_pkg_bump_ns_ew_8_6     pkg_bump_ns_ew_8_6     ref_gnd   curr_backgnd_PA_1_tile    * pwlfile = str(  )
	Icurr_pkg_bump_ns_ew_8_7     pkg_bump_ns_ew_8_7     ref_gnd   curr_backgnd_PA_1_tile    * pwlfile = str(  )
	Icurr_pkg_bump_ns_ew_9_0     pkg_bump_ns_ew_9_0     ref_gnd   curr_backgnd_MA_1_tile    * pwlfile = str(  )
	Icurr_pkg_bump_ns_ew_9_1     pkg_bump_ns_ew_9_1     ref_gnd   curr_backgnd_MA_1_tile    * pwlfile = str(  )
	Icurr_pkg_bump_ns_ew_9_2     pkg_bump_ns_ew_9_2     ref_gnd   curr_backgnd_MA_1_tile    * pwlfile = str(  )
	Icurr_pkg_bump_ns_ew_9_3     pkg_bump_ns_ew_9_3     ref_gnd   curr_backgnd_MA_1_tile    * pwlfile = str(  )
	Icurr_pkg_bump_ns_ew_9_4     pkg_bump_ns_ew_9_4     ref_gnd   curr_backgnd_PA_1_tile    * pwlfile = str(  )
	Icurr_pkg_bump_ns_ew_9_5     pkg_bump_ns_ew_9_5     ref_gnd   curr_backgnd_PA_1_tile    * pwlfile = str(  )
	Icurr_pkg_bump_ns_ew_9_6     pkg_bump_ns_ew_9_6     ref_gnd   curr_backgnd_PA_1_tile    * pwlfile = str(  )
	Icurr_pkg_bump_ns_ew_9_7     pkg_bump_ns_ew_9_7     ref_gnd   curr_backgnd_PA_1_tile    * pwlfile = str(  )
	Icurr_pkg_bump_ns_ew_10_0    pkg_bump_ns_ew_10_0    ref_gnd   curr_backgnd_MA_1_tile    * pwlfile = str(  )
	Icurr_pkg_bump_ns_ew_10_1    pkg_bump_ns_ew_10_1    ref_gnd   curr_backgnd_MA_1_tile    * pwlfile = str(  )
	Icurr_pkg_bump_ns_ew_10_2    pkg_bump_ns_ew_10_2    ref_gnd   curr_backgnd_MA_1_tile    * pwlfile = str(  )
	Icurr_pkg_bump_ns_ew_10_3    pkg_bump_ns_ew_10_3    ref_gnd   curr_backgnd_MA_1_tile    * pwlfile = str(  )
	Icurr_pkg_bump_ns_ew_10_4    pkg_bump_ns_ew_10_4    ref_gnd   curr_backgnd_PA_1_tile    * pwlfile = str(  )
	Icurr_pkg_bump_ns_ew_10_5    pkg_bump_ns_ew_10_5    ref_gnd   curr_backgnd_PA_1_tile    * pwlfile = str(  )
	Icurr_pkg_bump_ns_ew_10_6    pkg_bump_ns_ew_10_6    ref_gnd   curr_backgnd_PA_1_tile    * pwlfile = str(  )
	Icurr_pkg_bump_ns_ew_10_7    pkg_bump_ns_ew_10_7    ref_gnd   curr_backgnd_PA_1_tile    * pwlfile = str(  )
	Icurr_pkg_bump_ns_ew_11_0    pkg_bump_ns_ew_11_0    ref_gnd   curr_backgnd_MA_1_tile    * pwlfile = str(  )
	Icurr_pkg_bump_ns_ew_11_1    pkg_bump_ns_ew_11_1    ref_gnd   curr_backgnd_MA_1_tile    * pwlfile = str(  )
	Icurr_pkg_bump_ns_ew_11_2    pkg_bump_ns_ew_11_2    ref_gnd   curr_backgnd_MA_1_tile    * pwlfile = str(  )
	Icurr_pkg_bump_ns_ew_11_3    pkg_bump_ns_ew_11_3    ref_gnd   curr_backgnd_MA_1_tile    * pwlfile = str(  )
	Icurr_pkg_bump_ns_ew_11_4    pkg_bump_ns_ew_11_4    ref_gnd   curr_backgnd_PA_1_tile    * pwlfile = str(  )
	Icurr_pkg_bump_ns_ew_11_5    pkg_bump_ns_ew_11_5    ref_gnd   curr_backgnd_PA_1_tile    * pwlfile = str(  )
	Icurr_pkg_bump_ns_ew_11_6    pkg_bump_ns_ew_11_6    ref_gnd   curr_backgnd_PA_1_tile    * pwlfile = str(  )
	Icurr_pkg_bump_ns_ew_11_7    pkg_bump_ns_ew_11_7    ref_gnd   curr_backgnd_PA_1_tile    * pwlfile = str(  )

	Icurr_pkg_bump_ns_ew_12_0    pkg_bump_ns_ew_12_0    ref_gnd   curr_backgnd_MA_1_tile    * pwlfile = str(  )
	Icurr_pkg_bump_ns_ew_12_1    pkg_bump_ns_ew_12_1    ref_gnd   curr_backgnd_MA_1_tile    * pwlfile = str(  )
	Icurr_pkg_bump_ns_ew_12_2    pkg_bump_ns_ew_12_2    ref_gnd   curr_backgnd_MA_1_tile    * pwlfile = str(  )
	Icurr_pkg_bump_ns_ew_12_3    pkg_bump_ns_ew_12_3    ref_gnd   curr_backgnd_MA_1_tile    * pwlfile = str(  )
	Icurr_pkg_bump_ns_ew_12_4    pkg_bump_ns_ew_12_4    ref_gnd   curr_backgnd_PA_1_tile    * pwlfile = str(  )
	Icurr_pkg_bump_ns_ew_12_5    pkg_bump_ns_ew_12_5    ref_gnd   curr_backgnd_PA_1_tile    * pwlfile = str(  )
	Icurr_pkg_bump_ns_ew_12_6    pkg_bump_ns_ew_12_6    ref_gnd   curr_backgnd_PA_1_tile    * pwlfile = str(  )
	Icurr_pkg_bump_ns_ew_12_7    pkg_bump_ns_ew_12_7    ref_gnd   curr_backgnd_PA_1_tile    * pwlfile = str(  )
	Icurr_pkg_bump_ns_ew_13_0    pkg_bump_ns_ew_13_0    ref_gnd   curr_backgnd_MA_1_tile    * pwlfile = str(  )
	Icurr_pkg_bump_ns_ew_13_1    pkg_bump_ns_ew_13_1    ref_gnd   curr_backgnd_MA_1_tile    * pwlfile = str(  )
	Icurr_pkg_bump_ns_ew_13_2    pkg_bump_ns_ew_13_2    ref_gnd   curr_backgnd_MA_1_tile    * pwlfile = str(  )
	Icurr_pkg_bump_ns_ew_13_3    pkg_bump_ns_ew_13_3    ref_gnd   curr_backgnd_MA_1_tile    * pwlfile = str(  )
	Icurr_pkg_bump_ns_ew_13_4    pkg_bump_ns_ew_13_4    ref_gnd   curr_backgnd_PA_1_tile    * pwlfile = str(  )
	Icurr_pkg_bump_ns_ew_13_5    pkg_bump_ns_ew_13_5    ref_gnd   curr_backgnd_PA_1_tile    * pwlfile = str(  )
	Icurr_pkg_bump_ns_ew_13_6    pkg_bump_ns_ew_13_6    ref_gnd   curr_backgnd_PA_1_tile    * pwlfile = str(  )
	Icurr_pkg_bump_ns_ew_13_7    pkg_bump_ns_ew_13_7    ref_gnd   curr_backgnd_PA_1_tile    * pwlfile = str(  )
	Icurr_pkg_bump_ns_ew_14_0    pkg_bump_ns_ew_14_0    ref_gnd   curr_backgnd_MA_1_tile    * pwlfile = str(  )
	Icurr_pkg_bump_ns_ew_14_1    pkg_bump_ns_ew_14_1    ref_gnd   curr_backgnd_MA_1_tile    * pwlfile = str(  )
	Icurr_pkg_bump_ns_ew_14_2    pkg_bump_ns_ew_14_2    ref_gnd   curr_backgnd_MA_1_tile    * pwlfile = str(  )
	Icurr_pkg_bump_ns_ew_14_3    pkg_bump_ns_ew_14_3    ref_gnd   curr_backgnd_MA_1_tile    * pwlfile = str(  )
	Icurr_pkg_bump_ns_ew_14_4    pkg_bump_ns_ew_14_4    ref_gnd   curr_backgnd_PA_1_tile    * pwlfile = str(  )
	Icurr_pkg_bump_ns_ew_14_5    pkg_bump_ns_ew_14_5    ref_gnd   curr_backgnd_PA_1_tile    * pwlfile = str(  )
	Icurr_pkg_bump_ns_ew_14_6    pkg_bump_ns_ew_14_6    ref_gnd   curr_backgnd_PA_1_tile    * pwlfile = str(  )
	Icurr_pkg_bump_ns_ew_14_7    pkg_bump_ns_ew_14_7    ref_gnd   curr_backgnd_PA_1_tile    * pwlfile = str(  )
	Icurr_pkg_bump_ns_ew_15_0    pkg_bump_ns_ew_15_0    ref_gnd   curr_backgnd_MA_1_tile    * pwlfile = str(  )
	Icurr_pkg_bump_ns_ew_15_1    pkg_bump_ns_ew_15_1    ref_gnd   curr_backgnd_MA_1_tile    * pwlfile = str(  )
	Icurr_pkg_bump_ns_ew_15_2    pkg_bump_ns_ew_15_2    ref_gnd   curr_backgnd_MA_1_tile    * pwlfile = str(  )
	Icurr_pkg_bump_ns_ew_15_3    pkg_bump_ns_ew_15_3    ref_gnd   curr_backgnd_MA_1_tile    * pwlfile = str(  )
	Icurr_pkg_bump_ns_ew_15_4    pkg_bump_ns_ew_15_4    ref_gnd   curr_backgnd_PA_1_tile    * pwlfile = str(  )
	Icurr_pkg_bump_ns_ew_15_5    pkg_bump_ns_ew_15_5    ref_gnd   curr_backgnd_PA_1_tile    * pwlfile = str(  )
	Icurr_pkg_bump_ns_ew_15_6    pkg_bump_ns_ew_15_6    ref_gnd   curr_backgnd_PA_1_tile    * pwlfile = str(  )
	Icurr_pkg_bump_ns_ew_15_7    pkg_bump_ns_ew_15_7    ref_gnd   curr_backgnd_PA_1_tile    * pwlfile = str(  )
	Icurr_pkg_bump_ns_ew_16_0    pkg_bump_ns_ew_16_0    ref_gnd   curr_backgnd_MA_1_tile    * pwlfile = str(  )
	Icurr_pkg_bump_ns_ew_16_1    pkg_bump_ns_ew_16_1    ref_gnd   curr_backgnd_MA_1_tile    * pwlfile = str(  )
	Icurr_pkg_bump_ns_ew_16_2    pkg_bump_ns_ew_16_2    ref_gnd   curr_backgnd_MA_1_tile    * pwlfile = str(  )
	Icurr_pkg_bump_ns_ew_16_3    pkg_bump_ns_ew_16_3    ref_gnd   curr_backgnd_MA_1_tile    * pwlfile = str(  )
	Icurr_pkg_bump_ns_ew_16_4    pkg_bump_ns_ew_16_4    ref_gnd   curr_backgnd_PA_1_tile    * pwlfile = str(  )
	Icurr_pkg_bump_ns_ew_16_5    pkg_bump_ns_ew_16_5    ref_gnd   curr_backgnd_PA_1_tile    * pwlfile = str(  )
	Icurr_pkg_bump_ns_ew_16_6    pkg_bump_ns_ew_16_6    ref_gnd   curr_backgnd_PA_1_tile    * pwlfile = str(  )
	Icurr_pkg_bump_ns_ew_16_7    pkg_bump_ns_ew_16_7    ref_gnd   curr_backgnd_PA_1_tile    * pwlfile = str(  )
	Icurr_pkg_bump_ns_ew_17_0    pkg_bump_ns_ew_17_0    ref_gnd   curr_backgnd_MA_1_tile    * pwlfile = str(  )
	Icurr_pkg_bump_ns_ew_17_1    pkg_bump_ns_ew_17_1    ref_gnd   curr_backgnd_MA_1_tile    * pwlfile = str(  )
	Icurr_pkg_bump_ns_ew_17_2    pkg_bump_ns_ew_17_2    ref_gnd   curr_backgnd_MA_1_tile    * pwlfile = str(  )
	Icurr_pkg_bump_ns_ew_17_3    pkg_bump_ns_ew_17_3    ref_gnd   curr_backgnd_MA_1_tile    * pwlfile = str(  )
	Icurr_pkg_bump_ns_ew_17_4    pkg_bump_ns_ew_17_4    ref_gnd   curr_backgnd_PA_1_tile    * pwlfile = str(  )
	Icurr_pkg_bump_ns_ew_17_5    pkg_bump_ns_ew_17_5    ref_gnd   curr_backgnd_PA_1_tile    * pwlfile = str(  )
	Icurr_pkg_bump_ns_ew_17_6    pkg_bump_ns_ew_17_6    ref_gnd   curr_backgnd_PA_1_tile    * pwlfile = str(  )
	Icurr_pkg_bump_ns_ew_17_7    pkg_bump_ns_ew_17_7    ref_gnd   curr_backgnd_PA_1_tile    * pwlfile = str(  )
	Icurr_pkg_bump_ns_ew_18_0    pkg_bump_ns_ew_18_0    ref_gnd   curr_backgnd_MA_1_tile    * pwlfile = str(  )
	Icurr_pkg_bump_ns_ew_18_1    pkg_bump_ns_ew_18_1    ref_gnd   curr_backgnd_MA_1_tile    * pwlfile = str(  )
	Icurr_pkg_bump_ns_ew_18_2    pkg_bump_ns_ew_18_2    ref_gnd   curr_backgnd_MA_1_tile    * pwlfile = str(  )
	Icurr_pkg_bump_ns_ew_18_3    pkg_bump_ns_ew_18_3    ref_gnd   curr_backgnd_MA_1_tile    * pwlfile = str(  )
	Icurr_pkg_bump_ns_ew_18_4    pkg_bump_ns_ew_18_4    ref_gnd   curr_backgnd_PA_1_tile    * pwlfile = str(  )
	Icurr_pkg_bump_ns_ew_18_5    pkg_bump_ns_ew_18_5    ref_gnd   curr_backgnd_PA_1_tile    * pwlfile = str(  )
	Icurr_pkg_bump_ns_ew_18_6    pkg_bump_ns_ew_18_6    ref_gnd   curr_backgnd_PA_1_tile    * pwlfile = str(  )
	Icurr_pkg_bump_ns_ew_18_7    pkg_bump_ns_ew_18_7    ref_gnd   curr_backgnd_PA_1_tile    * pwlfile = str(  )

	Icurr_pkg_bump_ns_ew_19_0    pkg_bump_ns_ew_19_0    ref_gnd   curr_backgnd_MA_1_tile    * pwlfile = str(  )
	Icurr_pkg_bump_ns_ew_19_1    pkg_bump_ns_ew_19_1    ref_gnd   curr_backgnd_MA_1_tile    * pwlfile = str(  )
	Icurr_pkg_bump_ns_ew_19_2    pkg_bump_ns_ew_19_2    ref_gnd   curr_backgnd_MA_1_tile    * pwlfile = str(  )
	Icurr_pkg_bump_ns_ew_19_3    pkg_bump_ns_ew_19_3    ref_gnd   curr_backgnd_MA_1_tile    * pwlfile = str(  )
	Icurr_pkg_bump_ns_ew_19_4    pkg_bump_ns_ew_19_4    ref_gnd   curr_backgnd_PA_1_tile    * pwlfile = str(  )
	Icurr_pkg_bump_ns_ew_19_5    pkg_bump_ns_ew_19_5    ref_gnd   curr_backgnd_PA_1_tile    * pwlfile = str(  )
	Icurr_pkg_bump_ns_ew_19_6    pkg_bump_ns_ew_19_6    ref_gnd   curr_backgnd_PA_1_tile    * pwlfile = str(  )
	Icurr_pkg_bump_ns_ew_19_7    pkg_bump_ns_ew_19_7    ref_gnd   curr_backgnd_PA_1_tile    * pwlfile = str(  )
	Icurr_pkg_bump_ns_ew_20_0    pkg_bump_ns_ew_20_0    ref_gnd   curr_backgnd_MA_1_tile    * pwlfile = str(  )
	Icurr_pkg_bump_ns_ew_20_1    pkg_bump_ns_ew_20_1    ref_gnd   curr_backgnd_MA_1_tile    * pwlfile = str(  )
	Icurr_pkg_bump_ns_ew_20_2    pkg_bump_ns_ew_20_2    ref_gnd   curr_backgnd_MA_1_tile    * pwlfile = str(  )
	Icurr_pkg_bump_ns_ew_20_3    pkg_bump_ns_ew_20_3    ref_gnd   curr_backgnd_MA_1_tile    * pwlfile = str(  )
	Icurr_pkg_bump_ns_ew_20_4    pkg_bump_ns_ew_20_4    ref_gnd   curr_backgnd_PA_1_tile    * pwlfile = str(  )
	Icurr_pkg_bump_ns_ew_20_5    pkg_bump_ns_ew_20_5    ref_gnd   curr_backgnd_PA_1_tile    * pwlfile = str(  )
	Icurr_pkg_bump_ns_ew_20_6    pkg_bump_ns_ew_20_6    ref_gnd   curr_backgnd_PA_1_tile    * pwlfile = str(  )
	Icurr_pkg_bump_ns_ew_20_7    pkg_bump_ns_ew_20_7    ref_gnd   curr_backgnd_PA_1_tile    * pwlfile = str(  )
	Icurr_pkg_bump_ns_ew_21_0    pkg_bump_ns_ew_21_0    ref_gnd   curr_backgnd_MA_1_tile    * pwlfile = str(  )
	Icurr_pkg_bump_ns_ew_21_1    pkg_bump_ns_ew_21_1    ref_gnd   curr_backgnd_MA_1_tile    * pwlfile = str(  )
	Icurr_pkg_bump_ns_ew_21_2    pkg_bump_ns_ew_21_2    ref_gnd   curr_backgnd_MA_1_tile    * pwlfile = str(  )
	Icurr_pkg_bump_ns_ew_21_3    pkg_bump_ns_ew_21_3    ref_gnd   curr_backgnd_MA_1_tile    * pwlfile = str(  )
	Icurr_pkg_bump_ns_ew_21_4    pkg_bump_ns_ew_21_4    ref_gnd   curr_backgnd_PA_1_tile    * pwlfile = str(  )
	Icurr_pkg_bump_ns_ew_21_5    pkg_bump_ns_ew_21_5    ref_gnd   curr_backgnd_PA_1_tile    * pwlfile = str(  )
	Icurr_pkg_bump_ns_ew_21_6    pkg_bump_ns_ew_21_6    ref_gnd   curr_backgnd_PA_1_tile    * pwlfile = str(  )
	Icurr_pkg_bump_ns_ew_21_7    pkg_bump_ns_ew_21_7    ref_gnd   curr_backgnd_PA_1_tile    * pwlfile = str(  )
	Icurr_pkg_bump_ns_ew_22_0    pkg_bump_ns_ew_22_0    ref_gnd   curr_backgnd_MA_1_tile    * pwlfile = str(  )
	Icurr_pkg_bump_ns_ew_22_1    pkg_bump_ns_ew_22_1    ref_gnd   curr_backgnd_MA_1_tile    * pwlfile = str(  )
	Icurr_pkg_bump_ns_ew_22_2    pkg_bump_ns_ew_22_2    ref_gnd   curr_backgnd_MA_1_tile    * pwlfile = str(  )
	Icurr_pkg_bump_ns_ew_22_3    pkg_bump_ns_ew_22_3    ref_gnd   curr_backgnd_MA_1_tile    * pwlfile = str(  )
	Icurr_pkg_bump_ns_ew_22_4    pkg_bump_ns_ew_22_4    ref_gnd   curr_backgnd_PA_1_tile    * pwlfile = str(  )
	Icurr_pkg_bump_ns_ew_22_5    pkg_bump_ns_ew_22_5    ref_gnd   curr_backgnd_PA_1_tile    * pwlfile = str(  )
	Icurr_pkg_bump_ns_ew_22_6    pkg_bump_ns_ew_22_6    ref_gnd   curr_backgnd_PA_1_tile    * pwlfile = str(  )
	Icurr_pkg_bump_ns_ew_22_7    pkg_bump_ns_ew_22_7    ref_gnd   curr_backgnd_PA_1_tile    * pwlfile = str(  )
	Icurr_pkg_bump_ns_ew_23_0    pkg_bump_ns_ew_23_0    ref_gnd   curr_backgnd_MA_1_tile    * pwlfile = str(  )
	Icurr_pkg_bump_ns_ew_23_1    pkg_bump_ns_ew_23_1    ref_gnd   curr_backgnd_MA_1_tile    * pwlfile = str(  )
	Icurr_pkg_bump_ns_ew_23_2    pkg_bump_ns_ew_23_2    ref_gnd   curr_backgnd_MA_1_tile    * pwlfile = str(  )
	Icurr_pkg_bump_ns_ew_23_3    pkg_bump_ns_ew_23_3    ref_gnd   curr_backgnd_MA_1_tile    * pwlfile = str(  )
	Icurr_pkg_bump_ns_ew_23_4    pkg_bump_ns_ew_23_4    ref_gnd   curr_backgnd_PA_1_tile    * pwlfile = str(  )
	Icurr_pkg_bump_ns_ew_23_5    pkg_bump_ns_ew_23_5    ref_gnd   curr_backgnd_PA_1_tile    * pwlfile = str(  )
	Icurr_pkg_bump_ns_ew_23_6    pkg_bump_ns_ew_23_6    ref_gnd   curr_backgnd_PA_1_tile    * pwlfile = str(  )
	Icurr_pkg_bump_ns_ew_23_7    pkg_bump_ns_ew_23_7    ref_gnd   curr_backgnd_PA_1_tile    * pwlfile = str(  )

.endif

*** filter for measurement

X_probe_filter10
+ pkg_bump_ns_ew_23_7
+ ref_gnd
+ pkg_bump_ns_23_7_hf
+ pkg_bump_ns_23_7_lf
+ meas_filter

X_probe_filter13
+ pkg_bump_ns_ew_0_7
+ ref_gnd
+ pkg_bump_ns_0_7_hf
+ pkg_bump_ns_0_7_lf
+ meas_filter

* X_probe_filter_bga_0
* + bga_pcb_0
* + ref_gnd
* + bga_pcb_0_hf
* + bga_pcb_0_lf
* + meas_filter

*************************************** Analysis I: AC simulation *************
.if ( is_ac_run == 1 )
	.if ( 1 )
		*** NOTE: DO not include port def if tran analysis later
		P1 pkg_bump_ns_ew_0_7	ref_gnd	port=1	z0 = 0.1
		P2 pkg_bump_ns_ew_6_7	ref_gnd	port=2	z0 = 0.1
		P3 pkg_bump_ns_ew_18_7	ref_gnd	port=3	z0 = 0.1
		P4 pkg_bump_ns_ew_23_7	ref_gnd	port=4	z0 = 0.1

		P5 pkg_bump_ns_ew_1_7	ref_gnd	port=5	z0 = 0.1
		P6 pkg_bump_ns_ew_2_7	ref_gnd	port=6	z0 = 0.1
		P7 pkg_bump_ns_ew_3_7	ref_gnd	port=7	z0 = 0.1
		P8 pkg_bump_ns_ew_4_7	ref_gnd	port=8	z0 = 0.1
		P9 pkg_bump_ns_ew_5_7	ref_gnd	port=9	z0 = 0.1

			*** 8 bump grps ***
			* P1 pkg_bump_PA_ns_3	ref_gnd  port=1  z0 = 0.1
			* P2 pkg_bump_PA_ns_0	ref_gnd  port=2  z0 = 0.1
			******

		.lin 	sparcalc=1 	filename=impedance_plot	noisecalc=0 	gdcalc=0	format=touchstone 	dataformat=MA
		**.probe  ac s11(db) s11(p) s21(db) s21(p)
		.probe ac zin(1)(m) zin(1)(p) zin(2)(m) zin(2)(p) zin(3)(m) zin(3)(p) zin(4)(m) zin(4)(p)
		.probe ac zin(5)(m) zin(5)(p) zin(6)(m) zin(6)(p) zin(7)(m) zin(7)(p) zin(8)(m) zin(8)(p) zin(9)(m) zin(9)(p)

		.ac 	dec 50 1. 1.G

		*** transfer Z ***
		* I_dc_curr pkg_bump_ns_ew_0_7	ref_gnd	AC 1.
		* .probe ac v(pkg_bump_ns_ew_0_7)	v(pkg_bump_ns_ew_23_7)

	.endif

	.if ( 0 )
		*i_ac_pkg_bump_0_0 pkg_bump_MA_ns_3 ref_gnd dc=0 ac=-1.
		* .probe ac v(pkg_bump_MA_ns_3)

		i_ac_pkg_bump_1_0 pkg_bump_PA_ns_3 ref_gnd dc=0 ac=-1.
		.probe ac v(pkg_bump_PA_ns_3)	vi(pkg_bump_PA_ns_3)	vr(pkg_bump_PA_ns_3)

		.ac 	dec 50 1. 1.G

		* .param v_imag = vi(pkg_bump_PA_ns_3)
		* .param acl = 'v_imag / 2./pi '
		* .print 'vi(pkg_bump_PA_ns_3) / 2. '		*** works
				* .print 'vi(pkg_bump_PA_ns_3) / pi '						*** NOT work
				* .measure ac ACL param = 'vi(pkg_bump_PA_ns_3) / 2.'		*** NOT work

		.param pfreq = 100.e6
		.param dfreq = 10.e6
		.measure ac zval_1   find vi(pkg_bump_PA_ns_3)	at = 'pfreq - dfreq '
		.measure ac zval_2   find vi(pkg_bump_PA_ns_3)	at = 'pfreq + dfreq '
		.measure ac acl      param='(zval_2 - zval_1)/2./pi/(dfreq+dfreq)'

	.endif

.endif

*************************************** Analysis II: Transient simulation *****
.if ( is_ac_run != 1 )
	.tran tStep tSTOP
	*** edge partitions
	.probe tran v(pkg_bump_ns_ew_0_7)	v(pkg_bump_ns_ew_23_7)		*** corner grps
	.probe tran v(pkg_bump_ns_ew_6_7)	v(pkg_bump_ns_ew_18_7)		*** not so corner grps
	.probe tran v(pkg_bump_ns_ew_1_7) v(pkg_bump_ns_ew_2_7) v(pkg_bump_ns_ew_3_7) v(pkg_bump_ns_ew_4_7) v(pkg_bump_ns_ew_5_7) 	*** show progressive degradation of Vpp at beach front partition
	.probe tran v(pkg_bump_ns_ew_11_7)	v(pkg_bump_ns_ew_11_4)	v(pkg_bump_ns_ew_11_0)		***  center groups

	.probe tran v(pkg_bump_ns_23_7_hf)  v(pkg_bump_ns_23_7_hf)
	.probe tran v(pkg_bump_ns_0_7_hf)  v(pkg_bump_ns_0_7_hf)

	*** BGA
	.probe tran v(bga_0_0) v(bga_0_1) v(bga_0_2) v(bga_0_3)

	*** probe at Ecap area
	.probe tran v(pkge_Ecap1_2x2mm_2)  v(pkge_Ecap2_2x2mm_2)

	.probe tran v(pmic_pwr)

	*** probe current of each bump grp (per tile)
	* .probe 	x(Xblk_pkg.a_1)  x(Xblk_pkg.a_2)  x(Xblk_pkg.a_3)  x(Xblk_pkg.a_4)  x(Xblk_pkg.a_5)  x(Xblk_pkg.a_6)  x(Xblk_pkg.a_7)  x(Xblk_pkg.a_8)  x(Xblk_pkg.a_9)  x(Xblk_pkg.a_10)
  * + x(Xblk_pkg.a_11)  x(Xblk_pkg.a_12)  x(Xblk_pkg.a_13)  x(Xblk_pkg.a_14)  x(Xblk_pkg.a_15)  x(Xblk_pkg.a_16)  x(Xblk_pkg.a_17)  x(Xblk_pkg.a_18)  x(Xblk_pkg.a_19)  x(Xblk_pkg.a_20)
  * + x(Xblk_pkg.a_21)  x(Xblk_pkg.a_22)  x(Xblk_pkg.a_23)  x(Xblk_pkg.a_24)  x(Xblk_pkg.a_25)  x(Xblk_pkg.a_26)  x(Xblk_pkg.a_27)  x(Xblk_pkg.a_28)  x(Xblk_pkg.a_29)  x(Xblk_pkg.a_30)
  * + x(Xblk_pkg.a_31)  x(Xblk_pkg.a_32)  x(Xblk_pkg.a_33)  x(Xblk_pkg.a_34)  x(Xblk_pkg.a_35)  x(Xblk_pkg.a_36)  x(Xblk_pkg.a_37)  x(Xblk_pkg.a_38)  x(Xblk_pkg.a_39)  x(Xblk_pkg.a_40)
  * + x(Xblk_pkg.a_41)  x(Xblk_pkg.a_42)  x(Xblk_pkg.a_43)  x(Xblk_pkg.a_44)  x(Xblk_pkg.a_45)  x(Xblk_pkg.a_46)  x(Xblk_pkg.a_47)  x(Xblk_pkg.a_48)  x(Xblk_pkg.a_49)  x(Xblk_pkg.a_50)
  * + x(Xblk_pkg.a_51)  x(Xblk_pkg.a_52)  x(Xblk_pkg.a_53)  x(Xblk_pkg.a_54)  x(Xblk_pkg.a_55)  x(Xblk_pkg.a_56)  x(Xblk_pkg.a_57)  x(Xblk_pkg.a_58)  x(Xblk_pkg.a_59)  x(Xblk_pkg.a_60)
  * + x(Xblk_pkg.a_61)  x(Xblk_pkg.a_62)  x(Xblk_pkg.a_63)  x(Xblk_pkg.a_64)  x(Xblk_pkg.a_65)  x(Xblk_pkg.a_66)  x(Xblk_pkg.a_67)  x(Xblk_pkg.a_68)  x(Xblk_pkg.a_69)  x(Xblk_pkg.a_70)
  * + x(Xblk_pkg.a_71)  x(Xblk_pkg.a_72)  x(Xblk_pkg.a_73)  x(Xblk_pkg.a_74)  x(Xblk_pkg.a_75)  x(Xblk_pkg.a_76)  x(Xblk_pkg.a_77)  x(Xblk_pkg.a_78)  x(Xblk_pkg.a_79)  x(Xblk_pkg.a_80)
  * + x(Xblk_pkg.a_81)  x(Xblk_pkg.a_82)  x(Xblk_pkg.a_83)  x(Xblk_pkg.a_84)  x(Xblk_pkg.a_85)  x(Xblk_pkg.a_86)  x(Xblk_pkg.a_87)  x(Xblk_pkg.a_88)  x(Xblk_pkg.a_89)  x(Xblk_pkg.a_90)
  * + x(Xblk_pkg.a_91)  x(Xblk_pkg.a_92)  x(Xblk_pkg.a_93)  x(Xblk_pkg.a_94)  x(Xblk_pkg.a_95)  x(Xblk_pkg.a_96)  x(Xblk_pkg.a_97)  x(Xblk_pkg.a_98)  x(Xblk_pkg.a_99)  x(Xblk_pkg.a_100)
  * + x(Xblk_pkg.a_101)  x(Xblk_pkg.a_102)  x(Xblk_pkg.a_103)  x(Xblk_pkg.a_104)  x(Xblk_pkg.a_105)  x(Xblk_pkg.a_106)  x(Xblk_pkg.a_107)  x(Xblk_pkg.a_108)  x(Xblk_pkg.a_109)  x(Xblk_pkg.a_110)
  * + x(Xblk_pkg.a_111)  x(Xblk_pkg.a_112)  x(Xblk_pkg.a_113)  x(Xblk_pkg.a_114)  x(Xblk_pkg.a_115)  x(Xblk_pkg.a_116)  x(Xblk_pkg.a_117)  x(Xblk_pkg.a_118)  x(Xblk_pkg.a_119)  x(Xblk_pkg.a_120)
  * + x(Xblk_pkg.a_121)  x(Xblk_pkg.a_122)  x(Xblk_pkg.a_123)  x(Xblk_pkg.a_124)  x(Xblk_pkg.a_125)  x(Xblk_pkg.a_126)  x(Xblk_pkg.a_127)  x(Xblk_pkg.a_128)  x(Xblk_pkg.a_129)  x(Xblk_pkg.a_130)
  * + x(Xblk_pkg.a_131)  x(Xblk_pkg.a_132)  x(Xblk_pkg.a_133)  x(Xblk_pkg.a_134)  x(Xblk_pkg.a_135)  x(Xblk_pkg.a_136)  x(Xblk_pkg.a_137)  x(Xblk_pkg.a_138)  x(Xblk_pkg.a_139)  x(Xblk_pkg.a_140)
  * + x(Xblk_pkg.a_141)  x(Xblk_pkg.a_142)  x(Xblk_pkg.a_143)  x(Xblk_pkg.a_144)  x(Xblk_pkg.a_145)  x(Xblk_pkg.a_146)  x(Xblk_pkg.a_147)  x(Xblk_pkg.a_148)  x(Xblk_pkg.a_149)  x(Xblk_pkg.a_150)
  * + x(Xblk_pkg.a_151)  x(Xblk_pkg.a_152)  x(Xblk_pkg.a_153)  x(Xblk_pkg.a_154)  x(Xblk_pkg.a_155)  x(Xblk_pkg.a_156)  x(Xblk_pkg.a_157)  x(Xblk_pkg.a_158)  x(Xblk_pkg.a_159)  x(Xblk_pkg.a_160)
  * + x(Xblk_pkg.a_161)  x(Xblk_pkg.a_162)  x(Xblk_pkg.a_163)  x(Xblk_pkg.a_164)  x(Xblk_pkg.a_165)  x(Xblk_pkg.a_166)  x(Xblk_pkg.a_167)  x(Xblk_pkg.a_168)  x(Xblk_pkg.a_169)  x(Xblk_pkg.a_170)
  * + x(Xblk_pkg.a_171)  x(Xblk_pkg.a_172)  x(Xblk_pkg.a_173)  x(Xblk_pkg.a_174)  x(Xblk_pkg.a_175)  x(Xblk_pkg.a_176)  x(Xblk_pkg.a_177)  x(Xblk_pkg.a_178)  x(Xblk_pkg.a_179)  x(Xblk_pkg.a_180)
  * + x(Xblk_pkg.a_181)  x(Xblk_pkg.a_182)  x(Xblk_pkg.a_183)  x(Xblk_pkg.a_184)  x(Xblk_pkg.a_185)  x(Xblk_pkg.a_186)  x(Xblk_pkg.a_187)  x(Xblk_pkg.a_188)  x(Xblk_pkg.a_189)  x(Xblk_pkg.a_190)
  * + x(Xblk_pkg.a_191)  x(Xblk_pkg.a_192)

	* .probe x(Xblk_pkg.a_193) x(Xblk_pkg.a_194) x(Xblk_pkg.a_195) x(Xblk_pkg.a_196) x(Xblk_pkg.a_197) x(Xblk_pkg.a_198) x(Xblk_pkg.a_199) x(Xblk_pkg.a_200) x(Xblk_pkg.a_201)
	* + x(Xblk_pkg.a_202) x(Xblk_pkg.a_203) x(Xblk_pkg.a_204) x(Xblk_pkg.a_205) x(Xblk_pkg.a_206) x(Xblk_pkg.a_207) x(Xblk_pkg.a_208) x(Xblk_pkg.a_209) x(Xblk_pkg.a_210) x(Xblk_pkg.a_211) x(Xblk_pkg.a_212)
	* + x(Xblk_pkg.a_213) x(Xblk_pkg.a_214) x(Xblk_pkg.a_215) x(Xblk_pkg.a_216) x(Xblk_pkg.a_217) x(Xblk_pkg.a_218) x(Xblk_pkg.a_219) x(Xblk_pkg.a_220) x(Xblk_pkg.a_221) x(Xblk_pkg.a_222) x(Xblk_pkg.a_223)
	* + x(Xblk_pkg.a_224) x(Xblk_pkg.a_225) x(Xblk_pkg.a_226) x(Xblk_pkg.a_227) x(Xblk_pkg.a_228) x(Xblk_pkg.a_229) x(Xblk_pkg.a_230) x(Xblk_pkg.a_231) x(Xblk_pkg.a_232)

	.probe x(xblk_PMIC.pin_out)

.endif
